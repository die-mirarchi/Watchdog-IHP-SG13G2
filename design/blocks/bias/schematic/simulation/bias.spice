** sch_path: /workspace/design/blocks/bias/schematic/bias.sch
**.subckt bias VBP VBN VDD VSS
*.opin VBP
*.opin VBN
XM1 VBN VBN VSS VSS sg13_lv_nmos w=2u l=1u ng=1 m=1 mm_ok=1
XM2 VBP VBP VDD VDD sg13_lv_pmos w=2u l=1u ng=1 m=1 mm_ok=1
XR2 VBP VSS VSS rhigh w=0.5e-6 l=10.0e-6 m=1 b=0 mm_ok=1
XR1 VDD VBN VSS rhigh w=0.5e-6 l=10.0e-6 m=1 b=0 mm_ok=1
XC1 VBN VSS cap_cmim w=26.0e-6 l=26.0e-6 m=1 mm_ok=1
XC2 VDD VBP cap_cmim w=26.0e-6 l=26.0e-6 m=1 mm_ok=1
**.ends
.end
