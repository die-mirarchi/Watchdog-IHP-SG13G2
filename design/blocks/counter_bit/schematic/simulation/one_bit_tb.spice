** sch_path: /workspace/design/blocks/counter_bit/schematic/one_bit_tb.sch
**.subckt one_bit_tb
x1 Q POR_B CLK CI CLR VDD VSS one_bit
**** begin user architecture code

.lib cornerMOSlv.lib mos_ff
.lib cornerMOShv.lib mos_ff
.lib cornerHBT.lib hbt_typ
.lib cornerRES.lib res_typ
.lib cornerDIO.lib dio_tt
.lib cornerCAP.lib cap_typ

* ============================================================
* one_bit_tb.spice -- validacion funcional de one_bit (IHP SG13G2)
* D = (Q xor CI) and (not CLR) ; RESET_B asincronico = POR_B
* Corner MOS: editar la linea .lib (mos_tt / mos_ss / ...)
* Barre T = -40/27/85 C  x  VDD = 1.08/1.2/1.32 V dentro de .control
* CLK = 1 MHz (celda estatica: la funcion no depende de f; a 10 kHz
* ngspice da falsos flips del FF por paso de tiempo grande)
.global VDD VSS
.param vdd=1.2

* carga en Q: una entrada de celda (como el CI del bit siguiente)
xlq QB Q VDD VSS sg13g2_inv_1

* ---------- fuentes ----------
V_VDD VDD 0 PWL(0 0 100n {vdd})
V_VSS VSS 0 0
* CLK: flancos de subida en 0.5u + k*1u
V_CLK CLK 0 PULSE(0 {vdd} 0.5u 0.1n 0.1n 0.5u 1u)
* Entradas cambian en 0.2u + k*1u (300 ns de setup, 700 ns de hold)
V_POR POR_B 0 PWL(0 0 1.2u 0 1.2001u {vdd} 10.2u {vdd} 10.2001u 0 11.2u 0 11.2001u {vdd})
V_CI  CI    0 PWL(0 {vdd} 4.2u {vdd} 4.2001u 0 6.2u 0 6.2001u {vdd} 9.2u {vdd} 9.2001u 0 10.2u 0 10.2001u {vdd})
V_CLR CLR   0 PWL(0 0 6.2u 0 6.2001u {vdd} 8.2u {vdd} 8.2001u 0)

.option method=gear maxord=2 reltol=1e-3

.control
set noaskquit
* Secuencia esperada de Q (muestreo 300 ns despues de cada flanco):
*  E0   0.5u  POR_B=0, CI=1             -> 0  (reset domina)
*  E1   1.5u  CI=1 toggle               -> 1
*  E2   2.5u  CI=1 toggle               -> 0
*  E3   3.5u  CI=1 toggle               -> 1
*  E4   4.5u  CI=0 hold                 -> 1
*  E5   5.5u  CI=0 hold                 -> 1
*  E6   6.5u  CLR=1, CI=1 clear sincr.  -> 0
*  E7   7.5u  CLR=1 domina sobre CI     -> 0
*  E8   8.5u  CLR=0, CI=1 toggle        -> 1
*  E9   9.5u  CI=0 hold                 -> 1
*  A   10.3u  POR_B=0 en 10.2u (async)  -> 0  (sin flanco de CLK)
*  E10 10.5u  POR_B=0, CI=1             -> 0
*  E11 11.5u  POR_B=1, CI=1 toggle      -> 1
compose tchk values 0.8u 1.8u 2.8u 3.8u 4.8u 5.8u 6.8u 7.8u 8.8u 9.8u 10.3u 10.8u 11.8u
compose qexp values 0 1 0 1 1 1 0 0 1 1 0 0 1
let nchk = length(tchk)

compose tlist values -40 27 85
compose vlist values 1.08 1.2 1.32
let npass = 0
let ncase = 0

let it = 0
while it lt 3
 let iv = 0
 while iv lt 3
  let tt = tlist[it]
  let vv = vlist[iv]
  alterparam vdd = $&vv
  reset
  option temp = $&tt
  tran 0.5n 12u 0 1n
  * reintento si ngspice aborta ('timestep too small' = artefacto numerico)
  let nt = length(time)
  let tend = time[nt-1]
  if tend lt 11.9u
   echo REINTENTO T=$&tt VDD=$&vv con tmax=0.5n (aborto en t=$&tend)
   reset
   option temp = $&tt
   tran 0.25n 12u 0 0.5n
  end
  let vh = vv/2
  * --- 1) secuencia funcional ---
  let nok = 0
  let i = 0
  while i lt nchk
   let ts = tchk[i]
   meas tran qs FIND v(q) AT=$&ts
   let bit = qs gt vh
   let qe = qexp[i]
   if bit eq qe
    let nok = nok + 1
   else
    echo FALLA: t=$&ts Q=$&qs esperado=$&qe
   end
   let i = i + 1
  end
  * --- 2) sin glitches: exactamente 4 subidas y 3 bajadas de Q ---
  let r5 = -1
  let f4 = -1
  meas tran r5 WHEN v(q)=$&vh RISE=5
  meas tran f4 WHEN v(q)=$&vh FALL=4
  let noglitch = (r5 lt 0) & (f4 lt 0)
  * --- 3) tiempos: CLK->Q (E1) y POR_B->Q asincronico ---
  let tcq = -1
  let trq = -1
  meas tran tcq TRIG v(clk) VAL=$&vh RISE=2 TARG v(q) VAL=$&vh RISE=1
  meas tran trq TRIG v(por_b) VAL=$&vh FALL=1 TARG v(q) VAL=$&vh FALL=3
  * --- 4) Q_N complementaria ---
  meas tran qn1 FIND v(q_n) AT=11.8u
  meas tran qn0 FIND v(q_n) AT=7.8u
  let qnok = (qn1 lt vh) & (qn0 gt vh)
  let pass = (nok eq nchk) & noglitch & (tcq gt 0) & (tcq lt 1n) & (trq gt 0) & (trq lt 1n) & qnok
  let tcq_ps = tcq*1e12
  let trq_ps = trq*1e12
  if pass > 0.5
   echo CASO T=$&tt VDD=$&vv : PASS  muestras=$&nok/13 tCQ=$&tcq_ps ps tRST=$&trq_ps ps
   let npass = npass + 1
  else
   echo CASO T=$&tt VDD=$&vv : FAIL  muestras=$&nok/13 noglitch=$&noglitch tCQ=$&tcq_ps ps tRST=$&trq_ps ps QN=$&qnok
  end
  set wr_singlescale
  wrdata one_bit_{$&tt}_{$&vv}.txt v(clk) v(ci) v(clr) v(por_b) v(q)
  let ncase = ncase + 1
  let iv = iv + 1
 end
 let it = it + 1
end
echo ===============================================
echo RESUMEN: $&npass / $&ncase casos PASS
if npass eq ncase
 echo VEREDICTO: PASS
else
 echo VEREDICTO: FAIL
end
.endc
.end

**** end user architecture code
**.ends

* expanding   symbol:  one_bit.sym # of pins=5
** sym_path: /workspace/design/blocks/counter_bit/schematic/one_bit.sym
** sch_path: /workspace/design/blocks/counter_bit/schematic/one_bit.sch
.subckt one_bit Q POR_B CLK CI CLR VDD VSS
*.opin Q
*.ipin CLK
*.ipin POR_B
*.ipin CLR
*.ipin CI
x1 Q Q_N CLK D POR_B VDD VSS sg13g2_dfrbp_1
x2 D INC NCLR VDD VSS sg13g2_and2_1
x3 INC Q CI VDD VSS sg13g2_xor2_1
x4 NCLR CLR VDD VSS sg13g2_inv_1
.ends

* expanding   symbol:  sg13g2_dfrbp_1.sym # of pins=5
** sym_path: /foss/pdks/ihp-sg13g2/libs.ref/sg13g2_stdcell/sym/xschem/sg13g2_dfrbp_1.sym
** sch_path: /foss/pdks/ihp-sg13g2/libs.ref/sg13g2_stdcell/sch/xschem/sg13g2_dfrbp_1.sch
.subckt sg13g2_dfrbp_1 Q Q_N CLK D RESET_B VDD VSS

*.ipin D
*.ipin RESET_B
*.ipin CLK
*.opin Q
*.opin Q_N
XM1 Db D net12 VSS sg13_lv_nmos w=420.00n l=130.00n ng=1 m=1 mm_ok=1
XM2 net12 RESET_B VSS VSS sg13_lv_nmos w=420.00n l=130.00n ng=1 m=1 mm_ok=1
XM3 net2 clkneg net11 VSS sg13_lv_nmos w=420.00n l=130.00n ng=1 m=1 mm_ok=1
XM4 net11 net1 VSS VSS sg13_lv_nmos w=420.00n l=130.00n ng=1 m=1 mm_ok=1
XM5 net1 net2 net7 VSS sg13_lv_nmos w=420.00n l=130.00n ng=1 m=1 mm_ok=1
XM6 net7 RESET_B VSS VSS sg13_lv_nmos w=420.00n l=130.00n ng=1 m=1 mm_ok=1
XM7 Q_N net2 VSS VSS sg13_lv_nmos w=740.00n l=130.00n ng=1 m=1 mm_ok=1
XM8 net3 net2 VSS VSS sg13_lv_nmos w=740.00n l=130.00n ng=1 m=1 mm_ok=1
XM9 Q net3 VSS VSS sg13_lv_nmos w=740.00n l=130.00n ng=1 m=1 mm_ok=1
XM10 clkneg CLK VSS VSS sg13_lv_nmos w=740.00n l=130.00n ng=1 m=1 mm_ok=1
XM11 clkpos clkneg VSS VSS sg13_lv_nmos w=740.00n l=130.00n ng=1 m=1 mm_ok=1
XM12 Db clkneg net5 VSS sg13_lv_nmos w=420.00n l=130.00n ng=1 m=1 mm_ok=1
XM13 net5 clkpos net10 VSS sg13_lv_nmos w=420.00n l=130.00n ng=1 m=1 mm_ok=1
XM14 net10 net4 net6 VSS sg13_lv_nmos w=420.00n l=130.00n ng=1 m=1 mm_ok=1
XM15 net6 RESET_B VSS VSS sg13_lv_nmos w=420.00n l=130.00n ng=1 m=1 mm_ok=1
XM16 net4 net5 VSS VSS sg13_lv_nmos w=740.00n l=130.00n ng=1 m=1 mm_ok=1
XM17 net4 clkpos net2 VSS sg13_lv_nmos w=740.00n l=130.00n ng=1 m=1 mm_ok=1
XM18 Db RESET_B VDD VDD sg13_lv_pmos w=420.00n l=130.00n ng=1 m=1 mm_ok=1
XM19 Db D VDD VDD sg13_lv_pmos w=420.00n l=130.00n ng=1 m=1 mm_ok=1
XM20 net9 net1 VDD VDD sg13_lv_pmos w=420.00n l=130.00n ng=1 m=1 mm_ok=1
XM21 net2 clkpos net9 VDD sg13_lv_pmos w=420.00n l=130.00n ng=1 m=1 mm_ok=1
XM22 net1 net2 VDD VDD sg13_lv_pmos w=420.00n l=130.00n ng=1 m=1 mm_ok=1
XM23 net1 RESET_B VDD VDD sg13_lv_pmos w=420.00n l=130.00n ng=1 m=1 mm_ok=1
XM24 Q_N net2 VDD VDD sg13_lv_pmos w=1.12u l=130.00n ng=1 m=1 mm_ok=1
XM25 net3 net2 VDD VDD sg13_lv_pmos w=1.12u l=130.00n ng=1 m=1 mm_ok=1
XM26 Q net3 VDD VDD sg13_lv_pmos w=1.12u l=130.00n ng=1 m=1 mm_ok=1
XM27 clkneg CLK VDD VDD sg13_lv_pmos w=1.12u l=130.00n ng=1 m=1 mm_ok=1
XM28 clkpos clkneg VDD VDD sg13_lv_pmos w=1.12u l=130.00n ng=1 m=1 mm_ok=1
XM29 Db clkpos net5 VDD sg13_lv_pmos w=420.00n l=130.00n ng=1 m=1 mm_ok=1
XM30 net8 net4 VDD VDD sg13_lv_pmos w=420.00n l=130.00n ng=1 m=1 mm_ok=1
XM31 net5 clkneg net8 VDD sg13_lv_pmos w=420.00n l=130.00n ng=1 m=1 mm_ok=1
XM32 net5 RESET_B VDD VDD sg13_lv_pmos w=420.00n l=130.00n ng=1 m=1 mm_ok=1
XM33 net4 net5 VDD VDD sg13_lv_pmos w=1.000u l=130.00n ng=1 m=1 mm_ok=1
XM34 net4 clkneg net2 VDD sg13_lv_pmos w=1.000u l=130.00n ng=1 m=1 mm_ok=1
.ends

* expanding   symbol:  sg13g2_and2_1.sym # of pins=3
** sym_path: /foss/pdks/ihp-sg13g2/libs.ref/sg13g2_stdcell/sym/xschem/sg13g2_and2_1.sym
** sch_path: /foss/pdks/ihp-sg13g2/libs.ref/sg13g2_stdcell/sch/xschem/sg13g2_and2_1.sch
.subckt sg13g2_and2_1 X A B VDD VSS

*.ipin A
*.ipin B
*.opin X
XM1 net1 A net2 VSS sg13_lv_nmos w=640.00n l=130.00n ng=1 m=1 mm_ok=1
XM2 net2 B VSS VSS sg13_lv_nmos w=640.00n l=130.00n ng=1 m=1 mm_ok=1
XM3 X net1 VSS VSS sg13_lv_nmos w=740.00n l=130.00n ng=1 m=1 mm_ok=1
XM4 net1 B VDD VDD sg13_lv_pmos w=840.00n l=130.00n ng=1 m=1 mm_ok=1
XM5 net1 A VDD VDD sg13_lv_pmos w=840.00n l=130.00n ng=1 m=1 mm_ok=1
XM6 X net1 VDD VDD sg13_lv_pmos w=1.12u l=130.00n ng=1 m=1 mm_ok=1
.ends

* expanding   symbol:  sg13g2_xor2_1.sym # of pins=3
** sym_path: /foss/pdks/ihp-sg13g2/libs.ref/sg13g2_stdcell/sym/xschem/sg13g2_xor2_1.sym
** sch_path: /foss/pdks/ihp-sg13g2/libs.ref/sg13g2_stdcell/sch/xschem/sg13g2_xor2_1.sch
.subckt sg13g2_xor2_1 X A B VDD VSS

*.opin X
*.ipin B
*.ipin A
XM1 net1 A VSS VSS sg13_lv_nmos w=550.00n l=130.00n ng=1 m=1 mm_ok=1
XM2 net1 B VSS VSS sg13_lv_nmos w=550.00n l=130.00n ng=1 m=1 mm_ok=1
XM3 X net1 VSS VSS sg13_lv_nmos w=740.00n l=130.00n ng=1 m=1 mm_ok=1
XM4 X B net3 VSS sg13_lv_nmos w=740.00n l=130.00n ng=1 m=1 mm_ok=1
XM5 net3 A VSS VSS sg13_lv_nmos w=740.00n l=130.00n ng=1 m=1 mm_ok=1
XM6 net4 A VDD VDD sg13_lv_pmos w=1.000u l=130.00n ng=1 m=1 mm_ok=1
XM7 net1 B net4 VDD sg13_lv_pmos w=1.000u l=130.00n ng=1 m=1 mm_ok=1
XM8 net2 A VDD VDD sg13_lv_pmos w=1.12u l=130.00n ng=1 m=1 mm_ok=1
XM9 X net1 net2 VDD sg13_lv_pmos w=1.12u l=130.00n ng=1 m=1 mm_ok=1
XM10 net2 B VDD VDD sg13_lv_pmos w=1.12u l=130.00n ng=1 m=1 mm_ok=1
.ends

* expanding   symbol:  sg13g2_inv_1.sym # of pins=2
** sym_path: /foss/pdks/ihp-sg13g2/libs.ref/sg13g2_stdcell/sym/xschem/sg13g2_inv_1.sym
** sch_path: /foss/pdks/ihp-sg13g2/libs.ref/sg13g2_stdcell/sch/xschem/sg13g2_inv_1.sch
.subckt sg13g2_inv_1 Y A VDD VSS

*.opin Y
*.ipin A
XM1 Y A VSS VSS sg13_lv_nmos w=740.00n l=130.00n ng=1 m=1 mm_ok=1
XM2 Y A VDD VDD sg13_lv_pmos w=1.12u l=130.00n ng=1 m=1 mm_ok=1
.ends

.end
