** sch_path: /workspace/design/blocks/clkmon/schematic/wd_clkmon.sch
**.subckt wd_clkmon CLK CLK_LOST VDD VSS
*.ipin CLK
*.opin CLK_LOST
XMP0 G G VDD VDD sg13_lv_pmos w=0.5u l=0.5u ng=1 m=1 mm_ok=1
XMN0[14] G VDD VSS VSS sg13_lv_nmos w=0.15u l=200u ng=1 m=1 mm_ok=1
XMN0[13] G VDD VSS VSS sg13_lv_nmos w=0.15u l=200u ng=1 m=1 mm_ok=1
XMN0[12] G VDD VSS VSS sg13_lv_nmos w=0.15u l=200u ng=1 m=1 mm_ok=1
XMN0[11] G VDD VSS VSS sg13_lv_nmos w=0.15u l=200u ng=1 m=1 mm_ok=1
XMN0[10] G VDD VSS VSS sg13_lv_nmos w=0.15u l=200u ng=1 m=1 mm_ok=1
XMN0[9] G VDD VSS VSS sg13_lv_nmos w=0.15u l=200u ng=1 m=1 mm_ok=1
XMN0[8] G VDD VSS VSS sg13_lv_nmos w=0.15u l=200u ng=1 m=1 mm_ok=1
XMN0[7] G VDD VSS VSS sg13_lv_nmos w=0.15u l=200u ng=1 m=1 mm_ok=1
XMN0[6] G VDD VSS VSS sg13_lv_nmos w=0.15u l=200u ng=1 m=1 mm_ok=1
XMN0[5] G VDD VSS VSS sg13_lv_nmos w=0.15u l=200u ng=1 m=1 mm_ok=1
XMN0[4] G VDD VSS VSS sg13_lv_nmos w=0.15u l=200u ng=1 m=1 mm_ok=1
XMN0[3] G VDD VSS VSS sg13_lv_nmos w=0.15u l=200u ng=1 m=1 mm_ok=1
XMN0[2] G VDD VSS VSS sg13_lv_nmos w=0.15u l=200u ng=1 m=1 mm_ok=1
XMN0[1] G VDD VSS VSS sg13_lv_nmos w=0.15u l=200u ng=1 m=1 mm_ok=1
XMN0[0] G VDD VSS VSS sg13_lv_nmos w=0.15u l=200u ng=1 m=1 mm_ok=1
XMP1 A G VDD VDD sg13_lv_pmos w=0.15u l=10u ng=1 m=1 mm_ok=1
XCA A VSS cap_cmim w=28e-6 l=28e-6 m=1 mm_ok=1
XMN1 A CLKP VSS VSS sg13_lv_nmos w=0.5u l=0.13u ng=1 m=1 mm_ok=1
XMP2 B G VDD VDD sg13_lv_pmos w=0.15u l=10u ng=1 m=1 mm_ok=1
XCB B VSS cap_cmim w=28e-6 l=28e-6 m=1 mm_ok=1
XMN2 B CLKN VSS VSS sg13_lv_nmos w=0.5u l=0.13u ng=1 m=1 mm_ok=1
xi1 CLKN CLK VDD VSS sg13g2_inv_1
xi2 CLKP CLKN VDD VSS sg13g2_inv_1
xsa A SA VDD VSS schmitt
xsb B SB VDD VSS schmitt
xn CLK_LOST SA SB VDD VSS sg13g2_nand2_1
**.ends

* expanding   symbol:  sg13g2_inv_1.sym # of pins=2
** sym_path: /foss/pdks/ihp-sg13g2/libs.ref/sg13g2_stdcell/sym/xschem/sg13g2_inv_1.sym
** sch_path: /foss/pdks/ihp-sg13g2/libs.ref/sg13g2_stdcell/sch/xschem/sg13g2_inv_1.sch
.subckt sg13g2_inv_1 Y A VDD VSS

*.opin Y
*.ipin A
XM1 Y A VSS VSS sg13_lv_nmos w=740.00n l=130.00n ng=1 m=1 mm_ok=1
XM2 Y A VDD VDD sg13_lv_pmos w=1.12u l=130.00n ng=1 m=1 mm_ok=1
.ends

* expanding   symbol:  schmitt.sym # of pins=2
** sym_path: /workspace/design/blocks/schmitt/schematic/schmitt.sym
** sch_path: /workspace/design/blocks/schmitt/schematic/schmitt.sch
.subckt schmitt IN OUT VDD VSS
*.opin OUT
*.ipin IN
XM4 P_MID IN VDD VDD sg13_lv_pmos w=1.04u l=0.13u ng=1 m=1 mm_ok=1
XM6 OUT IN N_MID VSS sg13_lv_nmos w=0.76u l=0.13u ng=1 m=1 mm_ok=1
XM5 OUT IN P_MID VDD sg13_lv_pmos w=1.04u l=0.13u ng=1 m=1 mm_ok=1
XM7 N_MID IN VSS VSS sg13_lv_nmos w=0.76u l=0.13u ng=1 m=1 mm_ok=1
XM8 VSS OUT P_MID VDD sg13_lv_pmos w=0.42u l=0.13u ng=1 m=1 mm_ok=1
XM9 VDD OUT N_MID VSS sg13_lv_nmos w=0.42u l=0.13u ng=1 m=1 mm_ok=1
.ends

* expanding   symbol:  sg13g2_nand2_1.sym # of pins=3
** sym_path: /foss/pdks/ihp-sg13g2/libs.ref/sg13g2_stdcell/sym/xschem/sg13g2_nand2_1.sym
** sch_path: /foss/pdks/ihp-sg13g2/libs.ref/sg13g2_stdcell/sch/xschem/sg13g2_nand2_1.sch
.subckt sg13g2_nand2_1 Y A B VDD VSS

*.ipin A
*.ipin B
*.opin Y
XM1 Y A net1 VSS sg13_lv_nmos w=740.00n l=130.00n ng=1 m=1 mm_ok=1
XM2 net1 B VSS VSS sg13_lv_nmos w=740.00n l=130.00n ng=1 m=1 mm_ok=1
XM3 Y A VDD VDD sg13_lv_pmos w=1.12u l=130.00n ng=1 m=1 mm_ok=1
XM4 Y B VDD VDD sg13_lv_pmos w=1.12u l=130.00n ng=1 m=1 mm_ok=1
.ends

.end
