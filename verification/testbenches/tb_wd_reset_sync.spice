** =====================================================================
** tb_wd_reset_sync.spice -- validacion de wd_reset_sync (IHP SG13G2, ngspice 42 + OSDI)
** DUT: dos sg13g2_dfrbp_1 en cadena, D(F1)=VDD, RESET_B = POR_RAW_N, PORB = Q(F2).
**   Pines del subcircuito: CLK POR_RAW_N PORB VDD VSS (ajustar al .sym que dibujes).
** Reloj: fuente ideal 10 kHz -> sg13g2_buf_4 (igual que XCLOCK del oscilador) -> 200 fF
**   (~25 entradas de reloj + cableado). Para el caso lento: buf_1 + 1 pF.
** Estimulo: 8 liberaciones de POR_RAW_N con fase delta respecto de un flanco de subida
**   de CLK (-50u, -1u, -100n, -10n, -1n, 0, +1n, +10n) y 8 aserciones a mitad de ciclo.
** CRITERIOS por liberacion (VEREDICTO al final del log):
**   - PORB sube SOLO en un flanco de subida de CLK (fase 0..20 ns despues del flanco);
**   - entre 1 y 2 periodos despues de la liberacion (2.o flanco; 3.o si se perdio el 1.o);
**   - P1 sube exactamente un periodo antes que PORB (+-20 ns);
**   - un solo flanco de subida de PORB (sin pulsos);
**   - asercion asincronica: PORB baja <= 100 ns despues de POR_RAW_N.
** NUMERICA: VBK no tiene efecto electrico; fuerza pasos de 25 ps alrededor de cada flanco.
**   Sin VBK, con tmax 10-50 ns el FF cambia en el flanco de BAJADA (artefacto: maestro y
**   esclavo conmutan en el mismo paso). Si cambias los tiempos, regenera VBK.
** Los mensajes "measure tG.. out of interval" son ESPERADOS (no hubo segundo flanco).
** =====================================================================
.lib cornerMOSlv.lib mos_tt
.lib cornerRES.lib res_typ
.lib cornerCAP.lib cap_typ
.include sg13g2_stdcell.spice
.temp 27
.param VH=1.2
.option method=gear maxord=2 reltol=1e-3

** DUT
.subckt wd_reset_sync CLK POR_RAW_N PORB VDD VSS
XF1 P1 P1_N CLK VDD POR_RAW_N VDD VSS sg13g2_dfrbp_1
XF2 PORB PORB_N CLK P1 POR_RAW_N VDD VSS sg13g2_dfrbp_1
.ends

* alimentacion: rampa de 10 us
VDD VDD 0 PWL(0 0 10u {VH})
VSS VSS 0 0
* reloj: fuente ideal 10 kHz (flancos de subida en 50u + k*100u) -> buffer del oscilador -> carga del arbol de reloj
VCK CKI 0 PULSE(0 {VH} 50u 2n 2n 50u 100u)
XCKB CLK CKI VDD VSS sg13g2_buf_4
CCLK CLK 0 200f
* POR_RAW_N: 8 liberaciones con fase delta respecto del flanco (150u + 300u*s): -50u -1u -100n -10n -1n 0 1n 10n
*            y 8 aserciones a mitad de ciclo (390u + 300u*s)
VPOR POR_RAW_N 0 PWL(0 0 0.0001 0 0.000100001 {VH} 0.00039 {VH} 0.000390001 0 0.000449 0
+ 0.000449001 {VH} 0.00069 {VH} 0.000690001 0 0.0007499 0 0.000749901 {VH} 0.00099 {VH}
+ 0.000990001 0 0.00104999 0 0.001049991 {VH} 0.00129 {VH} 0.001290001 0 0.001349999 0
+ 0.00135 {VH} 0.00159 {VH} 0.001590001 0 0.00165 0 0.001650001 {VH} 0.00189 {VH}
+ 0.001890001 0 0.001950001 0 0.001950002 {VH} 0.00219 {VH} 0.002190001 0 0.00225001 0
+ 0.002250011 {VH} 0.00249 {VH} 0.002490001 0)
XDUT CLK POR_RAW_N PORB VDD VSS wd_reset_sync
* VBK: fuente auxiliar SIN efecto electrico. Solo pone puntos de quiebre cada 25 ps alrededor de
* cada flanco de CLK y de POR_RAW_N (-1 ns..+3 ns). Sin esto, con paso de decenas de ns el maestro
* y el esclavo del FF conmutan en el mismo paso y PORB cambia en el flanco de BAJADA (artefacto numerico).
VBK BK 0 PWL(0 0 4.9999e-05 0.001 4.9999025e-05 0 4.999905e-05 0.001 4.9999075e-05 0 4.99991e-05 0.001 4.9999125e-05 0 4.999915e-05 0.001
+ 4.9999175e-05 0 4.99992e-05 0.001 4.9999225e-05 0 4.999925e-05 0.001 4.9999275e-05 0 4.99993e-05 0.001 4.9999325e-05 0 4.999935e-05 0.001
+ 4.9999375e-05 0 4.99994e-05 0.001 4.9999425e-05 0 4.999945e-05 0.001 4.9999475e-05 0 4.99995e-05 0.001 4.9999525e-05 0 4.999955e-05 0.001
+ 4.9999575e-05 0 4.99996e-05 0.001 4.9999625e-05 0 4.999965e-05 0.001 4.9999675e-05 0 4.99997e-05 0.001 4.9999725e-05 0 4.999975e-05 0.001
+ 4.9999775e-05 0 4.99998e-05 0.001 4.9999825e-05 0 4.999985e-05 0.001 4.9999875e-05 0 4.99999e-05 0.001 4.9999925e-05 0 4.999995e-05 0.001
+ 4.9999975e-05 0 5e-05 0.001 5.0000025e-05 0 5.000005e-05 0.001 5.0000075e-05 0 5.00001e-05 0.001 5.0000125e-05 0 5.000015e-05 0.001
+ 5.0000175e-05 0 5.00002e-05 0.001 5.0000225e-05 0 5.000025e-05 0.001 5.0000275e-05 0 5.00003e-05 0.001 5.0000325e-05 0 5.000035e-05 0.001
+ 5.0000375e-05 0 5.00004e-05 0.001 5.0000425e-05 0 5.000045e-05 0.001 5.0000475e-05 0 5.00005e-05 0.001 5.0000525e-05 0 5.000055e-05 0.001
+ 5.0000575e-05 0 5.00006e-05 0.001 5.0000625e-05 0 5.000065e-05 0.001 5.0000675e-05 0 5.00007e-05 0.001 5.0000725e-05 0 5.000075e-05 0.001
+ 5.0000775e-05 0 5.00008e-05 0.001 5.0000825e-05 0 5.000085e-05 0.001 5.0000875e-05 0 5.00009e-05 0.001 5.0000925e-05 0 5.000095e-05 0.001
+ 5.0000975e-05 0 5.0001e-05 0.001 5.0001025e-05 0 5.000105e-05 0.001 5.0001075e-05 0 5.00011e-05 0.001 5.0001125e-05 0 5.000115e-05 0.001
+ 5.0001175e-05 0 5.00012e-05 0.001 5.0001225e-05 0 5.000125e-05 0.001 5.0001275e-05 0 5.00013e-05 0.001 5.0001325e-05 0 5.000135e-05 0.001
+ 5.0001375e-05 0 5.00014e-05 0.001 5.0001425e-05 0 5.000145e-05 0.001 5.0001475e-05 0 5.00015e-05 0.001 5.0001525e-05 0 5.000155e-05 0.001
+ 5.0001575e-05 0 5.00016e-05 0.001 5.0001625e-05 0 5.000165e-05 0.001 5.0001675e-05 0 5.00017e-05 0.001 5.0001725e-05 0 5.000175e-05 0.001
+ 5.0001775e-05 0 5.00018e-05 0.001 5.0001825e-05 0 5.000185e-05 0.001 5.0001875e-05 0 5.00019e-05 0.001 5.0001925e-05 0 5.000195e-05 0.001
+ 5.0001975e-05 0 5.0002e-05 0.001 5.0002025e-05 0 5.000205e-05 0.001 5.0002075e-05 0 5.00021e-05 0.001 5.0002125e-05 0 5.000215e-05 0.001
+ 5.0002175e-05 0 5.00022e-05 0.001 5.0002225e-05 0 5.000225e-05 0.001 5.0002275e-05 0 5.00023e-05 0.001 5.0002325e-05 0 5.000235e-05 0.001
+ 5.0002375e-05 0 5.00024e-05 0.001 5.0002425e-05 0 5.000245e-05 0.001 5.0002475e-05 0 5.00025e-05 0.001 5.0002525e-05 0 5.000255e-05 0.001
+ 5.0002575e-05 0 5.00026e-05 0.001 5.0002625e-05 0 5.000265e-05 0.001 5.0002675e-05 0 5.00027e-05 0.001 5.0002725e-05 0 5.000275e-05 0.001
+ 5.0002775e-05 0 5.00028e-05 0.001 5.0002825e-05 0 5.000285e-05 0.001 5.0002875e-05 0 5.00029e-05 0.001 5.0002925e-05 0 5.000295e-05 0.001
+ 5.0002975e-05 0 5.0003e-05 0.001 9.9999e-05 0 9.9999025e-05 0.001 9.999905e-05 0 9.9999075e-05 0.001 9.99991e-05 0 9.9999125e-05 0.001
+ 9.999915e-05 0 9.9999175e-05 0.001 9.99992e-05 0 9.9999225e-05 0.001 9.999925e-05 0 9.9999275e-05 0.001 9.99993e-05 0 9.9999325e-05 0.001
+ 9.999935e-05 0 9.9999375e-05 0.001 9.99994e-05 0 9.9999425e-05 0.001 9.999945e-05 0 9.9999475e-05 0.001 9.99995e-05 0 9.9999525e-05 0.001
+ 9.999955e-05 0 9.9999575e-05 0.001 9.99996e-05 0 9.9999625e-05 0.001 9.999965e-05 0 9.9999675e-05 0.001 9.99997e-05 0 9.9999725e-05 0.001
+ 9.999975e-05 0 9.9999775e-05 0.001 9.99998e-05 0 9.9999825e-05 0.001 9.999985e-05 0 9.9999875e-05 0.001 9.99999e-05 0 9.9999925e-05 0.001
+ 9.999995e-05 0 9.9999975e-05 0.001 0.0001 0 0.000100000025 0.001 0.00010000005 0 0.000100000075 0.001 0.0001000001 0 0.000100000125 0.001
+ 0.00010000015 0 0.000100000175 0.001 0.0001000002 0 0.000100000225 0.001 0.00010000025 0 0.000100000275 0.001 0.0001000003 0 0.000100000325 0.001
+ 0.00010000035 0 0.000100000375 0.001 0.0001000004 0 0.000100000425 0.001 0.00010000045 0 0.000100000475 0.001 0.0001000005 0 0.000100000525 0.001
+ 0.00010000055 0 0.000100000575 0.001 0.0001000006 0 0.000100000625 0.001 0.00010000065 0 0.000100000675 0.001 0.0001000007 0 0.000100000725 0.001
+ 0.00010000075 0 0.000100000775 0.001 0.0001000008 0 0.000100000825 0.001 0.00010000085 0 0.000100000875 0.001 0.0001000009 0 0.000100000925 0.001
+ 0.00010000095 0 0.000100000975 0.001 0.000100001 0 0.000100001025 0.001 0.00010000105 0 0.000100001075 0.001 0.0001000011 0 0.000100001125 0.001
+ 0.00010000115 0 0.000100001175 0.001 0.0001000012 0 0.000100001225 0.001 0.00010000125 0 0.000100001275 0.001 0.0001000013 0 0.000100001325 0.001
+ 0.00010000135 0 0.000100001375 0.001 0.0001000014 0 0.000100001425 0.001 0.00010000145 0 0.000100001475 0.001 0.0001000015 0 0.000100001525 0.001
+ 0.00010000155 0 0.000100001575 0.001 0.0001000016 0 0.000100001625 0.001 0.00010000165 0 0.000100001675 0.001 0.0001000017 0 0.000100001725 0.001
+ 0.00010000175 0 0.000100001775 0.001 0.0001000018 0 0.000100001825 0.001 0.00010000185 0 0.000100001875 0.001 0.0001000019 0 0.000100001925 0.001
+ 0.00010000195 0 0.000100001975 0.001 0.000100002 0 0.000100002025 0.001 0.00010000205 0 0.000100002075 0.001 0.0001000021 0 0.000100002125 0.001
+ 0.00010000215 0 0.000100002175 0.001 0.0001000022 0 0.000100002225 0.001 0.00010000225 0 0.000100002275 0.001 0.0001000023 0 0.000100002325 0.001
+ 0.00010000235 0 0.000100002375 0.001 0.0001000024 0 0.000100002425 0.001 0.00010000245 0 0.000100002475 0.001 0.0001000025 0 0.000100002525 0.001
+ 0.00010000255 0 0.000100002575 0.001 0.0001000026 0 0.000100002625 0.001 0.00010000265 0 0.000100002675 0.001 0.0001000027 0 0.000100002725 0.001
+ 0.00010000275 0 0.000100002775 0.001 0.0001000028 0 0.000100002825 0.001 0.00010000285 0 0.000100002875 0.001 0.0001000029 0 0.000100002925 0.001
+ 0.00010000295 0 0.000100002975 0.001 0.000100003 0 9.9999e-05 0.001 9.9999025e-05 0 9.999905e-05 0.001 9.9999075e-05 0 9.99991e-05 0.001
+ 9.9999125e-05 0 9.999915e-05 0.001 9.9999175e-05 0 9.99992e-05 0.001 9.9999225e-05 0 9.999925e-05 0.001 9.9999275e-05 0 9.99993e-05 0.001
+ 9.9999325e-05 0 9.999935e-05 0.001 9.9999375e-05 0 9.99994e-05 0.001 9.9999425e-05 0 9.999945e-05 0.001 9.9999475e-05 0 9.99995e-05 0.001
+ 9.9999525e-05 0 9.999955e-05 0.001 9.9999575e-05 0 9.99996e-05 0.001 9.9999625e-05 0 9.999965e-05 0.001 9.9999675e-05 0 9.99997e-05 0.001
+ 9.9999725e-05 0 9.999975e-05 0.001 9.9999775e-05 0 9.99998e-05 0.001 9.9999825e-05 0 9.999985e-05 0.001 9.9999875e-05 0 9.99999e-05 0.001
+ 9.9999925e-05 0 9.999995e-05 0.001 9.9999975e-05 0 0.0001 0.001 0.000100000025 0 0.00010000005 0.001 0.000100000075 0 0.0001000001 0.001
+ 0.000100000125 0 0.00010000015 0.001 0.000100000175 0 0.0001000002 0.001 0.000100000225 0 0.00010000025 0.001 0.000100000275 0 0.0001000003 0.001
+ 0.000100000325 0 0.00010000035 0.001 0.000100000375 0 0.0001000004 0.001 0.000100000425 0 0.00010000045 0.001 0.000100000475 0 0.0001000005 0.001
+ 0.000100000525 0 0.00010000055 0.001 0.000100000575 0 0.0001000006 0.001 0.000100000625 0 0.00010000065 0.001 0.000100000675 0 0.0001000007 0.001
+ 0.000100000725 0 0.00010000075 0.001 0.000100000775 0 0.0001000008 0.001 0.000100000825 0 0.00010000085 0.001 0.000100000875 0 0.0001000009 0.001
+ 0.000100000925 0 0.00010000095 0.001 0.000100000975 0 0.000100001 0.001 0.000100001025 0 0.00010000105 0.001 0.000100001075 0 0.0001000011 0.001
+ 0.000100001125 0 0.00010000115 0.001 0.000100001175 0 0.0001000012 0.001 0.000100001225 0 0.00010000125 0.001 0.000100001275 0 0.0001000013 0.001
+ 0.000100001325 0 0.00010000135 0.001 0.000100001375 0 0.0001000014 0.001 0.000100001425 0 0.00010000145 0.001 0.000100001475 0 0.0001000015 0.001
+ 0.000100001525 0 0.00010000155 0.001 0.000100001575 0 0.0001000016 0.001 0.000100001625 0 0.00010000165 0.001 0.000100001675 0 0.0001000017 0.001
+ 0.000100001725 0 0.00010000175 0.001 0.000100001775 0 0.0001000018 0.001 0.000100001825 0 0.00010000185 0.001 0.000100001875 0 0.0001000019 0.001
+ 0.000100001925 0 0.00010000195 0.001 0.000100001975 0 0.000100002 0.001 0.000100002025 0 0.00010000205 0.001 0.000100002075 0 0.0001000021 0.001
+ 0.000100002125 0 0.00010000215 0.001 0.000100002175 0 0.0001000022 0.001 0.000100002225 0 0.00010000225 0.001 0.000100002275 0 0.0001000023 0.001
+ 0.000100002325 0 0.00010000235 0.001 0.000100002375 0 0.0001000024 0.001 0.000100002425 0 0.00010000245 0.001 0.000100002475 0 0.0001000025 0.001
+ 0.000100002525 0 0.00010000255 0.001 0.000100002575 0 0.0001000026 0.001 0.000100002625 0 0.00010000265 0.001 0.000100002675 0 0.0001000027 0.001
+ 0.000100002725 0 0.00010000275 0.001 0.000100002775 0 0.0001000028 0.001 0.000100002825 0 0.00010000285 0.001 0.000100002875 0 0.0001000029 0.001
+ 0.000100002925 0 0.00010000295 0.001 0.000100002975 0 0.000100003 0.001 0.000149999 0 0.000149999025 0.001 0.00014999905 0 0.000149999075 0.001
+ 0.0001499991 0 0.000149999125 0.001 0.00014999915 0 0.000149999175 0.001 0.0001499992 0 0.000149999225 0.001 0.00014999925 0 0.000149999275 0.001
+ 0.0001499993 0 0.000149999325 0.001 0.00014999935 0 0.000149999375 0.001 0.0001499994 0 0.000149999425 0.001 0.00014999945 0 0.000149999475 0.001
+ 0.0001499995 0 0.000149999525 0.001 0.00014999955 0 0.000149999575 0.001 0.0001499996 0 0.000149999625 0.001 0.00014999965 0 0.000149999675 0.001
+ 0.0001499997 0 0.000149999725 0.001 0.00014999975 0 0.000149999775 0.001 0.0001499998 0 0.000149999825 0.001 0.00014999985 0 0.000149999875 0.001
+ 0.0001499999 0 0.000149999925 0.001 0.00014999995 0 0.000149999975 0.001 0.00015 0 0.000150000025 0.001 0.00015000005 0 0.000150000075 0.001
+ 0.0001500001 0 0.000150000125 0.001 0.00015000015 0 0.000150000175 0.001 0.0001500002 0 0.000150000225 0.001 0.00015000025 0 0.000150000275 0.001
+ 0.0001500003 0 0.000150000325 0.001 0.00015000035 0 0.000150000375 0.001 0.0001500004 0 0.000150000425 0.001 0.00015000045 0 0.000150000475 0.001
+ 0.0001500005 0 0.000150000525 0.001 0.00015000055 0 0.000150000575 0.001 0.0001500006 0 0.000150000625 0.001 0.00015000065 0 0.000150000675 0.001
+ 0.0001500007 0 0.000150000725 0.001 0.00015000075 0 0.000150000775 0.001 0.0001500008 0 0.000150000825 0.001 0.00015000085 0 0.000150000875 0.001
+ 0.0001500009 0 0.000150000925 0.001 0.00015000095 0 0.000150000975 0.001 0.000150001 0 0.000150001025 0.001 0.00015000105 0 0.000150001075 0.001
+ 0.0001500011 0 0.000150001125 0.001 0.00015000115 0 0.000150001175 0.001 0.0001500012 0 0.000150001225 0.001 0.00015000125 0 0.000150001275 0.001
+ 0.0001500013 0 0.000150001325 0.001 0.00015000135 0 0.000150001375 0.001 0.0001500014 0 0.000150001425 0.001 0.00015000145 0 0.000150001475 0.001
+ 0.0001500015 0 0.000150001525 0.001 0.00015000155 0 0.000150001575 0.001 0.0001500016 0 0.000150001625 0.001 0.00015000165 0 0.000150001675 0.001
+ 0.0001500017 0 0.000150001725 0.001 0.00015000175 0 0.000150001775 0.001 0.0001500018 0 0.000150001825 0.001 0.00015000185 0 0.000150001875 0.001
+ 0.0001500019 0 0.000150001925 0.001 0.00015000195 0 0.000150001975 0.001 0.000150002 0 0.000150002025 0.001 0.00015000205 0 0.000150002075 0.001
+ 0.0001500021 0 0.000150002125 0.001 0.00015000215 0 0.000150002175 0.001 0.0001500022 0 0.000150002225 0.001 0.00015000225 0 0.000150002275 0.001
+ 0.0001500023 0 0.000150002325 0.001 0.00015000235 0 0.000150002375 0.001 0.0001500024 0 0.000150002425 0.001 0.00015000245 0 0.000150002475 0.001
+ 0.0001500025 0 0.000150002525 0.001 0.00015000255 0 0.000150002575 0.001 0.0001500026 0 0.000150002625 0.001 0.00015000265 0 0.000150002675 0.001
+ 0.0001500027 0 0.000150002725 0.001 0.00015000275 0 0.000150002775 0.001 0.0001500028 0 0.000150002825 0.001 0.00015000285 0 0.000150002875 0.001
+ 0.0001500029 0 0.000150002925 0.001 0.00015000295 0 0.000150002975 0.001 0.000150003 0 0.000199999 0.001 0.000199999025 0 0.00019999905 0.001
+ 0.000199999075 0 0.0001999991 0.001 0.000199999125 0 0.00019999915 0.001 0.000199999175 0 0.0001999992 0.001 0.000199999225 0 0.00019999925 0.001
+ 0.000199999275 0 0.0001999993 0.001 0.000199999325 0 0.00019999935 0.001 0.000199999375 0 0.0001999994 0.001 0.000199999425 0 0.00019999945 0.001
+ 0.000199999475 0 0.0001999995 0.001 0.000199999525 0 0.00019999955 0.001 0.000199999575 0 0.0001999996 0.001 0.000199999625 0 0.00019999965 0.001
+ 0.000199999675 0 0.0001999997 0.001 0.000199999725 0 0.00019999975 0.001 0.000199999775 0 0.0001999998 0.001 0.000199999825 0 0.00019999985 0.001
+ 0.000199999875 0 0.0001999999 0.001 0.000199999925 0 0.00019999995 0.001 0.000199999975 0 0.0002 0.001 0.000200000025 0 0.00020000005 0.001
+ 0.000200000075 0 0.0002000001 0.001 0.000200000125 0 0.00020000015 0.001 0.000200000175 0 0.0002000002 0.001 0.000200000225 0 0.00020000025 0.001
+ 0.000200000275 0 0.0002000003 0.001 0.000200000325 0 0.00020000035 0.001 0.000200000375 0 0.0002000004 0.001 0.000200000425 0 0.00020000045 0.001
+ 0.000200000475 0 0.0002000005 0.001 0.000200000525 0 0.00020000055 0.001 0.000200000575 0 0.0002000006 0.001 0.000200000625 0 0.00020000065 0.001
+ 0.000200000675 0 0.0002000007 0.001 0.000200000725 0 0.00020000075 0.001 0.000200000775 0 0.0002000008 0.001 0.000200000825 0 0.00020000085 0.001
+ 0.000200000875 0 0.0002000009 0.001 0.000200000925 0 0.00020000095 0.001 0.000200000975 0 0.000200001 0.001 0.000200001025 0 0.00020000105 0.001
+ 0.000200001075 0 0.0002000011 0.001 0.000200001125 0 0.00020000115 0.001 0.000200001175 0 0.0002000012 0.001 0.000200001225 0 0.00020000125 0.001
+ 0.000200001275 0 0.0002000013 0.001 0.000200001325 0 0.00020000135 0.001 0.000200001375 0 0.0002000014 0.001 0.000200001425 0 0.00020000145 0.001
+ 0.000200001475 0 0.0002000015 0.001 0.000200001525 0 0.00020000155 0.001 0.000200001575 0 0.0002000016 0.001 0.000200001625 0 0.00020000165 0.001
+ 0.000200001675 0 0.0002000017 0.001 0.000200001725 0 0.00020000175 0.001 0.000200001775 0 0.0002000018 0.001 0.000200001825 0 0.00020000185 0.001
+ 0.000200001875 0 0.0002000019 0.001 0.000200001925 0 0.00020000195 0.001 0.000200001975 0 0.000200002 0.001 0.000200002025 0 0.00020000205 0.001
+ 0.000200002075 0 0.0002000021 0.001 0.000200002125 0 0.00020000215 0.001 0.000200002175 0 0.0002000022 0.001 0.000200002225 0 0.00020000225 0.001
+ 0.000200002275 0 0.0002000023 0.001 0.000200002325 0 0.00020000235 0.001 0.000200002375 0 0.0002000024 0.001 0.000200002425 0 0.00020000245 0.001
+ 0.000200002475 0 0.0002000025 0.001 0.000200002525 0 0.00020000255 0.001 0.000200002575 0 0.0002000026 0.001 0.000200002625 0 0.00020000265 0.001
+ 0.000200002675 0 0.0002000027 0.001 0.000200002725 0 0.00020000275 0.001 0.000200002775 0 0.0002000028 0.001 0.000200002825 0 0.00020000285 0.001
+ 0.000200002875 0 0.0002000029 0.001 0.000200002925 0 0.00020000295 0.001 0.000200002975 0 0.000200003 0.001 0.000249999 0 0.000249999025 0.001
+ 0.00024999905 0 0.000249999075 0.001 0.0002499991 0 0.000249999125 0.001 0.00024999915 0 0.000249999175 0.001 0.0002499992 0 0.000249999225 0.001
+ 0.00024999925 0 0.000249999275 0.001 0.0002499993 0 0.000249999325 0.001 0.00024999935 0 0.000249999375 0.001 0.0002499994 0 0.000249999425 0.001
+ 0.00024999945 0 0.000249999475 0.001 0.0002499995 0 0.000249999525 0.001 0.00024999955 0 0.000249999575 0.001 0.0002499996 0 0.000249999625 0.001
+ 0.00024999965 0 0.000249999675 0.001 0.0002499997 0 0.000249999725 0.001 0.00024999975 0 0.000249999775 0.001 0.0002499998 0 0.000249999825 0.001
+ 0.00024999985 0 0.000249999875 0.001 0.0002499999 0 0.000249999925 0.001 0.00024999995 0 0.000249999975 0.001 0.00025 0 0.000250000025 0.001
+ 0.00025000005 0 0.000250000075 0.001 0.0002500001 0 0.000250000125 0.001 0.00025000015 0 0.000250000175 0.001 0.0002500002 0 0.000250000225 0.001
+ 0.00025000025 0 0.000250000275 0.001 0.0002500003 0 0.000250000325 0.001 0.00025000035 0 0.000250000375 0.001 0.0002500004 0 0.000250000425 0.001
+ 0.00025000045 0 0.000250000475 0.001 0.0002500005 0 0.000250000525 0.001 0.00025000055 0 0.000250000575 0.001 0.0002500006 0 0.000250000625 0.001
+ 0.00025000065 0 0.000250000675 0.001 0.0002500007 0 0.000250000725 0.001 0.00025000075 0 0.000250000775 0.001 0.0002500008 0 0.000250000825 0.001
+ 0.00025000085 0 0.000250000875 0.001 0.0002500009 0 0.000250000925 0.001 0.00025000095 0 0.000250000975 0.001 0.000250001 0 0.000250001025 0.001
+ 0.00025000105 0 0.000250001075 0.001 0.0002500011 0 0.000250001125 0.001 0.00025000115 0 0.000250001175 0.001 0.0002500012 0 0.000250001225 0.001
+ 0.00025000125 0 0.000250001275 0.001 0.0002500013 0 0.000250001325 0.001 0.00025000135 0 0.000250001375 0.001 0.0002500014 0 0.000250001425 0.001
+ 0.00025000145 0 0.000250001475 0.001 0.0002500015 0 0.000250001525 0.001 0.00025000155 0 0.000250001575 0.001 0.0002500016 0 0.000250001625 0.001
+ 0.00025000165 0 0.000250001675 0.001 0.0002500017 0 0.000250001725 0.001 0.00025000175 0 0.000250001775 0.001 0.0002500018 0 0.000250001825 0.001
+ 0.00025000185 0 0.000250001875 0.001 0.0002500019 0 0.000250001925 0.001 0.00025000195 0 0.000250001975 0.001 0.000250002 0 0.000250002025 0.001
+ 0.00025000205 0 0.000250002075 0.001 0.0002500021 0 0.000250002125 0.001 0.00025000215 0 0.000250002175 0.001 0.0002500022 0 0.000250002225 0.001
+ 0.00025000225 0 0.000250002275 0.001 0.0002500023 0 0.000250002325 0.001 0.00025000235 0 0.000250002375 0.001 0.0002500024 0 0.000250002425 0.001
+ 0.00025000245 0 0.000250002475 0.001 0.0002500025 0 0.000250002525 0.001 0.00025000255 0 0.000250002575 0.001 0.0002500026 0 0.000250002625 0.001
+ 0.00025000265 0 0.000250002675 0.001 0.0002500027 0 0.000250002725 0.001 0.00025000275 0 0.000250002775 0.001 0.0002500028 0 0.000250002825 0.001
+ 0.00025000285 0 0.000250002875 0.001 0.0002500029 0 0.000250002925 0.001 0.00025000295 0 0.000250002975 0.001 0.000250003 0 0.000299999 0.001
+ 0.000299999025 0 0.00029999905 0.001 0.000299999075 0 0.0002999991 0.001 0.000299999125 0 0.00029999915 0.001 0.000299999175 0 0.0002999992 0.001
+ 0.000299999225 0 0.00029999925 0.001 0.000299999275 0 0.0002999993 0.001 0.000299999325 0 0.00029999935 0.001 0.000299999375 0 0.0002999994 0.001
+ 0.000299999425 0 0.00029999945 0.001 0.000299999475 0 0.0002999995 0.001 0.000299999525 0 0.00029999955 0.001 0.000299999575 0 0.0002999996 0.001
+ 0.000299999625 0 0.00029999965 0.001 0.000299999675 0 0.0002999997 0.001 0.000299999725 0 0.00029999975 0.001 0.000299999775 0 0.0002999998 0.001
+ 0.000299999825 0 0.00029999985 0.001 0.000299999875 0 0.0002999999 0.001 0.000299999925 0 0.00029999995 0.001 0.000299999975 0 0.0003 0.001
+ 0.000300000025 0 0.00030000005 0.001 0.000300000075 0 0.0003000001 0.001 0.000300000125 0 0.00030000015 0.001 0.000300000175 0 0.0003000002 0.001
+ 0.000300000225 0 0.00030000025 0.001 0.000300000275 0 0.0003000003 0.001 0.000300000325 0 0.00030000035 0.001 0.000300000375 0 0.0003000004 0.001
+ 0.000300000425 0 0.00030000045 0.001 0.000300000475 0 0.0003000005 0.001 0.000300000525 0 0.00030000055 0.001 0.000300000575 0 0.0003000006 0.001
+ 0.000300000625 0 0.00030000065 0.001 0.000300000675 0 0.0003000007 0.001 0.000300000725 0 0.00030000075 0.001 0.000300000775 0 0.0003000008 0.001
+ 0.000300000825 0 0.00030000085 0.001 0.000300000875 0 0.0003000009 0.001 0.000300000925 0 0.00030000095 0.001 0.000300000975 0 0.000300001 0.001
+ 0.000300001025 0 0.00030000105 0.001 0.000300001075 0 0.0003000011 0.001 0.000300001125 0 0.00030000115 0.001 0.000300001175 0 0.0003000012 0.001
+ 0.000300001225 0 0.00030000125 0.001 0.000300001275 0 0.0003000013 0.001 0.000300001325 0 0.00030000135 0.001 0.000300001375 0 0.0003000014 0.001
+ 0.000300001425 0 0.00030000145 0.001 0.000300001475 0 0.0003000015 0.001 0.000300001525 0 0.00030000155 0.001 0.000300001575 0 0.0003000016 0.001
+ 0.000300001625 0 0.00030000165 0.001 0.000300001675 0 0.0003000017 0.001 0.000300001725 0 0.00030000175 0.001 0.000300001775 0 0.0003000018 0.001
+ 0.000300001825 0 0.00030000185 0.001 0.000300001875 0 0.0003000019 0.001 0.000300001925 0 0.00030000195 0.001 0.000300001975 0 0.000300002 0.001
+ 0.000300002025 0 0.00030000205 0.001 0.000300002075 0 0.0003000021 0.001 0.000300002125 0 0.00030000215 0.001 0.000300002175 0 0.0003000022 0.001
+ 0.000300002225 0 0.00030000225 0.001 0.000300002275 0 0.0003000023 0.001 0.000300002325 0 0.00030000235 0.001 0.000300002375 0 0.0003000024 0.001
+ 0.000300002425 0 0.00030000245 0.001 0.000300002475 0 0.0003000025 0.001 0.000300002525 0 0.00030000255 0.001 0.000300002575 0 0.0003000026 0.001
+ 0.000300002625 0 0.00030000265 0.001 0.000300002675 0 0.0003000027 0.001 0.000300002725 0 0.00030000275 0.001 0.000300002775 0 0.0003000028 0.001
+ 0.000300002825 0 0.00030000285 0.001 0.000300002875 0 0.0003000029 0.001 0.000300002925 0 0.00030000295 0.001 0.000300002975 0 0.000300003 0.001
+ 0.000349999 0 0.000349999025 0.001 0.00034999905 0 0.000349999075 0.001 0.0003499991 0 0.000349999125 0.001 0.00034999915 0 0.000349999175 0.001
+ 0.0003499992 0 0.000349999225 0.001 0.00034999925 0 0.000349999275 0.001 0.0003499993 0 0.000349999325 0.001 0.00034999935 0 0.000349999375 0.001
+ 0.0003499994 0 0.000349999425 0.001 0.00034999945 0 0.000349999475 0.001 0.0003499995 0 0.000349999525 0.001 0.00034999955 0 0.000349999575 0.001
+ 0.0003499996 0 0.000349999625 0.001 0.00034999965 0 0.000349999675 0.001 0.0003499997 0 0.000349999725 0.001 0.00034999975 0 0.000349999775 0.001
+ 0.0003499998 0 0.000349999825 0.001 0.00034999985 0 0.000349999875 0.001 0.0003499999 0 0.000349999925 0.001 0.00034999995 0 0.000349999975 0.001
+ 0.00035 0 0.000350000025 0.001 0.00035000005 0 0.000350000075 0.001 0.0003500001 0 0.000350000125 0.001 0.00035000015 0 0.000350000175 0.001
+ 0.0003500002 0 0.000350000225 0.001 0.00035000025 0 0.000350000275 0.001 0.0003500003 0 0.000350000325 0.001 0.00035000035 0 0.000350000375 0.001
+ 0.0003500004 0 0.000350000425 0.001 0.00035000045 0 0.000350000475 0.001 0.0003500005 0 0.000350000525 0.001 0.00035000055 0 0.000350000575 0.001
+ 0.0003500006 0 0.000350000625 0.001 0.00035000065 0 0.000350000675 0.001 0.0003500007 0 0.000350000725 0.001 0.00035000075 0 0.000350000775 0.001
+ 0.0003500008 0 0.000350000825 0.001 0.00035000085 0 0.000350000875 0.001 0.0003500009 0 0.000350000925 0.001 0.00035000095 0 0.000350000975 0.001
+ 0.000350001 0 0.000350001025 0.001 0.00035000105 0 0.000350001075 0.001 0.0003500011 0 0.000350001125 0.001 0.00035000115 0 0.000350001175 0.001
+ 0.0003500012 0 0.000350001225 0.001 0.00035000125 0 0.000350001275 0.001 0.0003500013 0 0.000350001325 0.001 0.00035000135 0 0.000350001375 0.001
+ 0.0003500014 0 0.000350001425 0.001 0.00035000145 0 0.000350001475 0.001 0.0003500015 0 0.000350001525 0.001 0.00035000155 0 0.000350001575 0.001
+ 0.0003500016 0 0.000350001625 0.001 0.00035000165 0 0.000350001675 0.001 0.0003500017 0 0.000350001725 0.001 0.00035000175 0 0.000350001775 0.001
+ 0.0003500018 0 0.000350001825 0.001 0.00035000185 0 0.000350001875 0.001 0.0003500019 0 0.000350001925 0.001 0.00035000195 0 0.000350001975 0.001
+ 0.000350002 0 0.000350002025 0.001 0.00035000205 0 0.000350002075 0.001 0.0003500021 0 0.000350002125 0.001 0.00035000215 0 0.000350002175 0.001
+ 0.0003500022 0 0.000350002225 0.001 0.00035000225 0 0.000350002275 0.001 0.0003500023 0 0.000350002325 0.001 0.00035000235 0 0.000350002375 0.001
+ 0.0003500024 0 0.000350002425 0.001 0.00035000245 0 0.000350002475 0.001 0.0003500025 0 0.000350002525 0.001 0.00035000255 0 0.000350002575 0.001
+ 0.0003500026 0 0.000350002625 0.001 0.00035000265 0 0.000350002675 0.001 0.0003500027 0 0.000350002725 0.001 0.00035000275 0 0.000350002775 0.001
+ 0.0003500028 0 0.000350002825 0.001 0.00035000285 0 0.000350002875 0.001 0.0003500029 0 0.000350002925 0.001 0.00035000295 0 0.000350002975 0.001
+ 0.000350003 0 0.000389999 0.001 0.000389999025 0 0.00038999905 0.001 0.000389999075 0 0.0003899991 0.001 0.000389999125 0 0.00038999915 0.001
+ 0.000389999175 0 0.0003899992 0.001 0.000389999225 0 0.00038999925 0.001 0.000389999275 0 0.0003899993 0.001 0.000389999325 0 0.00038999935 0.001
+ 0.000389999375 0 0.0003899994 0.001 0.000389999425 0 0.00038999945 0.001 0.000389999475 0 0.0003899995 0.001 0.000389999525 0 0.00038999955 0.001
+ 0.000389999575 0 0.0003899996 0.001 0.000389999625 0 0.00038999965 0.001 0.000389999675 0 0.0003899997 0.001 0.000389999725 0 0.00038999975 0.001
+ 0.000389999775 0 0.0003899998 0.001 0.000389999825 0 0.00038999985 0.001 0.000389999875 0 0.0003899999 0.001 0.000389999925 0 0.00038999995 0.001
+ 0.000389999975 0 0.00039 0.001 0.000390000025 0 0.00039000005 0.001 0.000390000075 0 0.0003900001 0.001 0.000390000125 0 0.00039000015 0.001
+ 0.000390000175 0 0.0003900002 0.001 0.000390000225 0 0.00039000025 0.001 0.000390000275 0 0.0003900003 0.001 0.000390000325 0 0.00039000035 0.001
+ 0.000390000375 0 0.0003900004 0.001 0.000390000425 0 0.00039000045 0.001 0.000390000475 0 0.0003900005 0.001 0.000390000525 0 0.00039000055 0.001
+ 0.000390000575 0 0.0003900006 0.001 0.000390000625 0 0.00039000065 0.001 0.000390000675 0 0.0003900007 0.001 0.000390000725 0 0.00039000075 0.001
+ 0.000390000775 0 0.0003900008 0.001 0.000390000825 0 0.00039000085 0.001 0.000390000875 0 0.0003900009 0.001 0.000390000925 0 0.00039000095 0.001
+ 0.000390000975 0 0.000390001 0.001 0.000390001025 0 0.00039000105 0.001 0.000390001075 0 0.0003900011 0.001 0.000390001125 0 0.00039000115 0.001
+ 0.000390001175 0 0.0003900012 0.001 0.000390001225 0 0.00039000125 0.001 0.000390001275 0 0.0003900013 0.001 0.000390001325 0 0.00039000135 0.001
+ 0.000390001375 0 0.0003900014 0.001 0.000390001425 0 0.00039000145 0.001 0.000390001475 0 0.0003900015 0.001 0.000390001525 0 0.00039000155 0.001
+ 0.000390001575 0 0.0003900016 0.001 0.000390001625 0 0.00039000165 0.001 0.000390001675 0 0.0003900017 0.001 0.000390001725 0 0.00039000175 0.001
+ 0.000390001775 0 0.0003900018 0.001 0.000390001825 0 0.00039000185 0.001 0.000390001875 0 0.0003900019 0.001 0.000390001925 0 0.00039000195 0.001
+ 0.000390001975 0 0.000390002 0.001 0.000390002025 0 0.00039000205 0.001 0.000390002075 0 0.0003900021 0.001 0.000390002125 0 0.00039000215 0.001
+ 0.000390002175 0 0.0003900022 0.001 0.000390002225 0 0.00039000225 0.001 0.000390002275 0 0.0003900023 0.001 0.000390002325 0 0.00039000235 0.001
+ 0.000390002375 0 0.0003900024 0.001 0.000390002425 0 0.00039000245 0.001 0.000390002475 0 0.0003900025 0.001 0.000390002525 0 0.00039000255 0.001
+ 0.000390002575 0 0.0003900026 0.001 0.000390002625 0 0.00039000265 0.001 0.000390002675 0 0.0003900027 0.001 0.000390002725 0 0.00039000275 0.001
+ 0.000390002775 0 0.0003900028 0.001 0.000390002825 0 0.00039000285 0.001 0.000390002875 0 0.0003900029 0.001 0.000390002925 0 0.00039000295 0.001
+ 0.000390002975 0 0.000390003 0.001 0.000399999 0 0.000399999025 0.001 0.00039999905 0 0.000399999075 0.001 0.0003999991 0 0.000399999125 0.001
+ 0.00039999915 0 0.000399999175 0.001 0.0003999992 0 0.000399999225 0.001 0.00039999925 0 0.000399999275 0.001 0.0003999993 0 0.000399999325 0.001
+ 0.00039999935 0 0.000399999375 0.001 0.0003999994 0 0.000399999425 0.001 0.00039999945 0 0.000399999475 0.001 0.0003999995 0 0.000399999525 0.001
+ 0.00039999955 0 0.000399999575 0.001 0.0003999996 0 0.000399999625 0.001 0.00039999965 0 0.000399999675 0.001 0.0003999997 0 0.000399999725 0.001
+ 0.00039999975 0 0.000399999775 0.001 0.0003999998 0 0.000399999825 0.001 0.00039999985 0 0.000399999875 0.001 0.0003999999 0 0.000399999925 0.001
+ 0.00039999995 0 0.000399999975 0.001 0.0004 0 0.000400000025 0.001 0.00040000005 0 0.000400000075 0.001 0.0004000001 0 0.000400000125 0.001
+ 0.00040000015 0 0.000400000175 0.001 0.0004000002 0 0.000400000225 0.001 0.00040000025 0 0.000400000275 0.001 0.0004000003 0 0.000400000325 0.001
+ 0.00040000035 0 0.000400000375 0.001 0.0004000004 0 0.000400000425 0.001 0.00040000045 0 0.000400000475 0.001 0.0004000005 0 0.000400000525 0.001
+ 0.00040000055 0 0.000400000575 0.001 0.0004000006 0 0.000400000625 0.001 0.00040000065 0 0.000400000675 0.001 0.0004000007 0 0.000400000725 0.001
+ 0.00040000075 0 0.000400000775 0.001 0.0004000008 0 0.000400000825 0.001 0.00040000085 0 0.000400000875 0.001 0.0004000009 0 0.000400000925 0.001
+ 0.00040000095 0 0.000400000975 0.001 0.000400001 0 0.000400001025 0.001 0.00040000105 0 0.000400001075 0.001 0.0004000011 0 0.000400001125 0.001
+ 0.00040000115 0 0.000400001175 0.001 0.0004000012 0 0.000400001225 0.001 0.00040000125 0 0.000400001275 0.001 0.0004000013 0 0.000400001325 0.001
+ 0.00040000135 0 0.000400001375 0.001 0.0004000014 0 0.000400001425 0.001 0.00040000145 0 0.000400001475 0.001 0.0004000015 0 0.000400001525 0.001
+ 0.00040000155 0 0.000400001575 0.001 0.0004000016 0 0.000400001625 0.001 0.00040000165 0 0.000400001675 0.001 0.0004000017 0 0.000400001725 0.001
+ 0.00040000175 0 0.000400001775 0.001 0.0004000018 0 0.000400001825 0.001 0.00040000185 0 0.000400001875 0.001 0.0004000019 0 0.000400001925 0.001
+ 0.00040000195 0 0.000400001975 0.001 0.000400002 0 0.000400002025 0.001 0.00040000205 0 0.000400002075 0.001 0.0004000021 0 0.000400002125 0.001
+ 0.00040000215 0 0.000400002175 0.001 0.0004000022 0 0.000400002225 0.001 0.00040000225 0 0.000400002275 0.001 0.0004000023 0 0.000400002325 0.001
+ 0.00040000235 0 0.000400002375 0.001 0.0004000024 0 0.000400002425 0.001 0.00040000245 0 0.000400002475 0.001 0.0004000025 0 0.000400002525 0.001
+ 0.00040000255 0 0.000400002575 0.001 0.0004000026 0 0.000400002625 0.001 0.00040000265 0 0.000400002675 0.001 0.0004000027 0 0.000400002725 0.001
+ 0.00040000275 0 0.000400002775 0.001 0.0004000028 0 0.000400002825 0.001 0.00040000285 0 0.000400002875 0.001 0.0004000029 0 0.000400002925 0.001
+ 0.00040000295 0 0.000400002975 0.001 0.000400003 0 0.000448999 0.001 0.000448999025 0 0.00044899905 0.001 0.000448999075 0 0.0004489991 0.001
+ 0.000448999125 0 0.00044899915 0.001 0.000448999175 0 0.0004489992 0.001 0.000448999225 0 0.00044899925 0.001 0.000448999275 0 0.0004489993 0.001
+ 0.000448999325 0 0.00044899935 0.001 0.000448999375 0 0.0004489994 0.001 0.000448999425 0 0.00044899945 0.001 0.000448999475 0 0.0004489995 0.001
+ 0.000448999525 0 0.00044899955 0.001 0.000448999575 0 0.0004489996 0.001 0.000448999625 0 0.00044899965 0.001 0.000448999675 0 0.0004489997 0.001
+ 0.000448999725 0 0.00044899975 0.001 0.000448999775 0 0.0004489998 0.001 0.000448999825 0 0.00044899985 0.001 0.000448999875 0 0.0004489999 0.001
+ 0.000448999925 0 0.00044899995 0.001 0.000448999975 0 0.000449 0.001 0.000449000025 0 0.00044900005 0.001 0.000449000075 0 0.0004490001 0.001
+ 0.000449000125 0 0.00044900015 0.001 0.000449000175 0 0.0004490002 0.001 0.000449000225 0 0.00044900025 0.001 0.000449000275 0 0.0004490003 0.001
+ 0.000449000325 0 0.00044900035 0.001 0.000449000375 0 0.0004490004 0.001 0.000449000425 0 0.00044900045 0.001 0.000449000475 0 0.0004490005 0.001
+ 0.000449000525 0 0.00044900055 0.001 0.000449000575 0 0.0004490006 0.001 0.000449000625 0 0.00044900065 0.001 0.000449000675 0 0.0004490007 0.001
+ 0.000449000725 0 0.00044900075 0.001 0.000449000775 0 0.0004490008 0.001 0.000449000825 0 0.00044900085 0.001 0.000449000875 0 0.0004490009 0.001
+ 0.000449000925 0 0.00044900095 0.001 0.000449000975 0 0.000449001 0.001 0.000449001025 0 0.00044900105 0.001 0.000449001075 0 0.0004490011 0.001
+ 0.000449001125 0 0.00044900115 0.001 0.000449001175 0 0.0004490012 0.001 0.000449001225 0 0.00044900125 0.001 0.000449001275 0 0.0004490013 0.001
+ 0.000449001325 0 0.00044900135 0.001 0.000449001375 0 0.0004490014 0.001 0.000449001425 0 0.00044900145 0.001 0.000449001475 0 0.0004490015 0.001
+ 0.000449001525 0 0.00044900155 0.001 0.000449001575 0 0.0004490016 0.001 0.000449001625 0 0.00044900165 0.001 0.000449001675 0 0.0004490017 0.001
+ 0.000449001725 0 0.00044900175 0.001 0.000449001775 0 0.0004490018 0.001 0.000449001825 0 0.00044900185 0.001 0.000449001875 0 0.0004490019 0.001
+ 0.000449001925 0 0.00044900195 0.001 0.000449001975 0 0.000449002 0.001 0.000449002025 0 0.00044900205 0.001 0.000449002075 0 0.0004490021 0.001
+ 0.000449002125 0 0.00044900215 0.001 0.000449002175 0 0.0004490022 0.001 0.000449002225 0 0.00044900225 0.001 0.000449002275 0 0.0004490023 0.001
+ 0.000449002325 0 0.00044900235 0.001 0.000449002375 0 0.0004490024 0.001 0.000449002425 0 0.00044900245 0.001 0.000449002475 0 0.0004490025 0.001
+ 0.000449002525 0 0.00044900255 0.001 0.000449002575 0 0.0004490026 0.001 0.000449002625 0 0.00044900265 0.001 0.000449002675 0 0.0004490027 0.001
+ 0.000449002725 0 0.00044900275 0.001 0.000449002775 0 0.0004490028 0.001 0.000449002825 0 0.00044900285 0.001 0.000449002875 0 0.0004490029 0.001
+ 0.000449002925 0 0.00044900295 0.001 0.000449002975 0 0.000449003 0.001 0.000449999 0 0.000449999025 0.001 0.00044999905 0 0.000449999075 0.001
+ 0.0004499991 0 0.000449999125 0.001 0.00044999915 0 0.000449999175 0.001 0.0004499992 0 0.000449999225 0.001 0.00044999925 0 0.000449999275 0.001
+ 0.0004499993 0 0.000449999325 0.001 0.00044999935 0 0.000449999375 0.001 0.0004499994 0 0.000449999425 0.001 0.00044999945 0 0.000449999475 0.001
+ 0.0004499995 0 0.000449999525 0.001 0.00044999955 0 0.000449999575 0.001 0.0004499996 0 0.000449999625 0.001 0.00044999965 0 0.000449999675 0.001
+ 0.0004499997 0 0.000449999725 0.001 0.00044999975 0 0.000449999775 0.001 0.0004499998 0 0.000449999825 0.001 0.00044999985 0 0.000449999875 0.001
+ 0.0004499999 0 0.000449999925 0.001 0.00044999995 0 0.000449999975 0.001 0.00045 0 0.000450000025 0.001 0.00045000005 0 0.000450000075 0.001
+ 0.0004500001 0 0.000450000125 0.001 0.00045000015 0 0.000450000175 0.001 0.0004500002 0 0.000450000225 0.001 0.00045000025 0 0.000450000275 0.001
+ 0.0004500003 0 0.000450000325 0.001 0.00045000035 0 0.000450000375 0.001 0.0004500004 0 0.000450000425 0.001 0.00045000045 0 0.000450000475 0.001
+ 0.0004500005 0 0.000450000525 0.001 0.00045000055 0 0.000450000575 0.001 0.0004500006 0 0.000450000625 0.001 0.00045000065 0 0.000450000675 0.001
+ 0.0004500007 0 0.000450000725 0.001 0.00045000075 0 0.000450000775 0.001 0.0004500008 0 0.000450000825 0.001 0.00045000085 0 0.000450000875 0.001
+ 0.0004500009 0 0.000450000925 0.001 0.00045000095 0 0.000450000975 0.001 0.000450001 0 0.000450001025 0.001 0.00045000105 0 0.000450001075 0.001
+ 0.0004500011 0 0.000450001125 0.001 0.00045000115 0 0.000450001175 0.001 0.0004500012 0 0.000450001225 0.001 0.00045000125 0 0.000450001275 0.001
+ 0.0004500013 0 0.000450001325 0.001 0.00045000135 0 0.000450001375 0.001 0.0004500014 0 0.000450001425 0.001 0.00045000145 0 0.000450001475 0.001
+ 0.0004500015 0 0.000450001525 0.001 0.00045000155 0 0.000450001575 0.001 0.0004500016 0 0.000450001625 0.001 0.00045000165 0 0.000450001675 0.001
+ 0.0004500017 0 0.000450001725 0.001 0.00045000175 0 0.000450001775 0.001 0.0004500018 0 0.000450001825 0.001 0.00045000185 0 0.000450001875 0.001
+ 0.0004500019 0 0.000450001925 0.001 0.00045000195 0 0.000450001975 0.001 0.000450002 0 0.000450002025 0.001 0.00045000205 0 0.000450002075 0.001
+ 0.0004500021 0 0.000450002125 0.001 0.00045000215 0 0.000450002175 0.001 0.0004500022 0 0.000450002225 0.001 0.00045000225 0 0.000450002275 0.001
+ 0.0004500023 0 0.000450002325 0.001 0.00045000235 0 0.000450002375 0.001 0.0004500024 0 0.000450002425 0.001 0.00045000245 0 0.000450002475 0.001
+ 0.0004500025 0 0.000450002525 0.001 0.00045000255 0 0.000450002575 0.001 0.0004500026 0 0.000450002625 0.001 0.00045000265 0 0.000450002675 0.001
+ 0.0004500027 0 0.000450002725 0.001 0.00045000275 0 0.000450002775 0.001 0.0004500028 0 0.000450002825 0.001 0.00045000285 0 0.000450002875 0.001
+ 0.0004500029 0 0.000450002925 0.001 0.00045000295 0 0.000450002975 0.001 0.000450003 0 0.000499999 0.001 0.000499999025 0 0.00049999905 0.001
+ 0.000499999075 0 0.0004999991 0.001 0.000499999125 0 0.00049999915 0.001 0.000499999175 0 0.0004999992 0.001 0.000499999225 0 0.00049999925 0.001
+ 0.000499999275 0 0.0004999993 0.001 0.000499999325 0 0.00049999935 0.001 0.000499999375 0 0.0004999994 0.001 0.000499999425 0 0.00049999945 0.001
+ 0.000499999475 0 0.0004999995 0.001 0.000499999525 0 0.00049999955 0.001 0.000499999575 0 0.0004999996 0.001 0.000499999625 0 0.00049999965 0.001
+ 0.000499999675 0 0.0004999997 0.001 0.000499999725 0 0.00049999975 0.001 0.000499999775 0 0.0004999998 0.001 0.000499999825 0 0.00049999985 0.001
+ 0.000499999875 0 0.0004999999 0.001 0.000499999925 0 0.00049999995 0.001 0.000499999975 0 0.0005 0.001 0.000500000025 0 0.00050000005 0.001
+ 0.000500000075 0 0.0005000001 0.001 0.000500000125 0 0.00050000015 0.001 0.000500000175 0 0.0005000002 0.001 0.000500000225 0 0.00050000025 0.001
+ 0.000500000275 0 0.0005000003 0.001 0.000500000325 0 0.00050000035 0.001 0.000500000375 0 0.0005000004 0.001 0.000500000425 0 0.00050000045 0.001
+ 0.000500000475 0 0.0005000005 0.001 0.000500000525 0 0.00050000055 0.001 0.000500000575 0 0.0005000006 0.001 0.000500000625 0 0.00050000065 0.001
+ 0.000500000675 0 0.0005000007 0.001 0.000500000725 0 0.00050000075 0.001 0.000500000775 0 0.0005000008 0.001 0.000500000825 0 0.00050000085 0.001
+ 0.000500000875 0 0.0005000009 0.001 0.000500000925 0 0.00050000095 0.001 0.000500000975 0 0.000500001 0.001 0.000500001025 0 0.00050000105 0.001
+ 0.000500001075 0 0.0005000011 0.001 0.000500001125 0 0.00050000115 0.001 0.000500001175 0 0.0005000012 0.001 0.000500001225 0 0.00050000125 0.001
+ 0.000500001275 0 0.0005000013 0.001 0.000500001325 0 0.00050000135 0.001 0.000500001375 0 0.0005000014 0.001 0.000500001425 0 0.00050000145 0.001
+ 0.000500001475 0 0.0005000015 0.001 0.000500001525 0 0.00050000155 0.001 0.000500001575 0 0.0005000016 0.001 0.000500001625 0 0.00050000165 0.001
+ 0.000500001675 0 0.0005000017 0.001 0.000500001725 0 0.00050000175 0.001 0.000500001775 0 0.0005000018 0.001 0.000500001825 0 0.00050000185 0.001
+ 0.000500001875 0 0.0005000019 0.001 0.000500001925 0 0.00050000195 0.001 0.000500001975 0 0.000500002 0.001 0.000500002025 0 0.00050000205 0.001
+ 0.000500002075 0 0.0005000021 0.001 0.000500002125 0 0.00050000215 0.001 0.000500002175 0 0.0005000022 0.001 0.000500002225 0 0.00050000225 0.001
+ 0.000500002275 0 0.0005000023 0.001 0.000500002325 0 0.00050000235 0.001 0.000500002375 0 0.0005000024 0.001 0.000500002425 0 0.00050000245 0.001
+ 0.000500002475 0 0.0005000025 0.001 0.000500002525 0 0.00050000255 0.001 0.000500002575 0 0.0005000026 0.001 0.000500002625 0 0.00050000265 0.001
+ 0.000500002675 0 0.0005000027 0.001 0.000500002725 0 0.00050000275 0.001 0.000500002775 0 0.0005000028 0.001 0.000500002825 0 0.00050000285 0.001
+ 0.000500002875 0 0.0005000029 0.001 0.000500002925 0 0.00050000295 0.001 0.000500002975 0 0.000500003 0.001 0.000549999 0 0.000549999025 0.001
+ 0.00054999905 0 0.000549999075 0.001 0.0005499991 0 0.000549999125 0.001 0.00054999915 0 0.000549999175 0.001 0.0005499992 0 0.000549999225 0.001
+ 0.00054999925 0 0.000549999275 0.001 0.0005499993 0 0.000549999325 0.001 0.00054999935 0 0.000549999375 0.001 0.0005499994 0 0.000549999425 0.001
+ 0.00054999945 0 0.000549999475 0.001 0.0005499995 0 0.000549999525 0.001 0.00054999955 0 0.000549999575 0.001 0.0005499996 0 0.000549999625 0.001
+ 0.00054999965 0 0.000549999675 0.001 0.0005499997 0 0.000549999725 0.001 0.00054999975 0 0.000549999775 0.001 0.0005499998 0 0.000549999825 0.001
+ 0.00054999985 0 0.000549999875 0.001 0.0005499999 0 0.000549999925 0.001 0.00054999995 0 0.000549999975 0.001 0.00055 0 0.000550000025 0.001
+ 0.00055000005 0 0.000550000075 0.001 0.0005500001 0 0.000550000125 0.001 0.00055000015 0 0.000550000175 0.001 0.0005500002 0 0.000550000225 0.001
+ 0.00055000025 0 0.000550000275 0.001 0.0005500003 0 0.000550000325 0.001 0.00055000035 0 0.000550000375 0.001 0.0005500004 0 0.000550000425 0.001
+ 0.00055000045 0 0.000550000475 0.001 0.0005500005 0 0.000550000525 0.001 0.00055000055 0 0.000550000575 0.001 0.0005500006 0 0.000550000625 0.001
+ 0.00055000065 0 0.000550000675 0.001 0.0005500007 0 0.000550000725 0.001 0.00055000075 0 0.000550000775 0.001 0.0005500008 0 0.000550000825 0.001
+ 0.00055000085 0 0.000550000875 0.001 0.0005500009 0 0.000550000925 0.001 0.00055000095 0 0.000550000975 0.001 0.000550001 0 0.000550001025 0.001
+ 0.00055000105 0 0.000550001075 0.001 0.0005500011 0 0.000550001125 0.001 0.00055000115 0 0.000550001175 0.001 0.0005500012 0 0.000550001225 0.001
+ 0.00055000125 0 0.000550001275 0.001 0.0005500013 0 0.000550001325 0.001 0.00055000135 0 0.000550001375 0.001 0.0005500014 0 0.000550001425 0.001
+ 0.00055000145 0 0.000550001475 0.001 0.0005500015 0 0.000550001525 0.001 0.00055000155 0 0.000550001575 0.001 0.0005500016 0 0.000550001625 0.001
+ 0.00055000165 0 0.000550001675 0.001 0.0005500017 0 0.000550001725 0.001 0.00055000175 0 0.000550001775 0.001 0.0005500018 0 0.000550001825 0.001
+ 0.00055000185 0 0.000550001875 0.001 0.0005500019 0 0.000550001925 0.001 0.00055000195 0 0.000550001975 0.001 0.000550002 0 0.000550002025 0.001
+ 0.00055000205 0 0.000550002075 0.001 0.0005500021 0 0.000550002125 0.001 0.00055000215 0 0.000550002175 0.001 0.0005500022 0 0.000550002225 0.001
+ 0.00055000225 0 0.000550002275 0.001 0.0005500023 0 0.000550002325 0.001 0.00055000235 0 0.000550002375 0.001 0.0005500024 0 0.000550002425 0.001
+ 0.00055000245 0 0.000550002475 0.001 0.0005500025 0 0.000550002525 0.001 0.00055000255 0 0.000550002575 0.001 0.0005500026 0 0.000550002625 0.001
+ 0.00055000265 0 0.000550002675 0.001 0.0005500027 0 0.000550002725 0.001 0.00055000275 0 0.000550002775 0.001 0.0005500028 0 0.000550002825 0.001
+ 0.00055000285 0 0.000550002875 0.001 0.0005500029 0 0.000550002925 0.001 0.00055000295 0 0.000550002975 0.001 0.000550003 0 0.000599999 0.001
+ 0.000599999025 0 0.00059999905 0.001 0.000599999075 0 0.0005999991 0.001 0.000599999125 0 0.00059999915 0.001 0.000599999175 0 0.0005999992 0.001
+ 0.000599999225 0 0.00059999925 0.001 0.000599999275 0 0.0005999993 0.001 0.000599999325 0 0.00059999935 0.001 0.000599999375 0 0.0005999994 0.001
+ 0.000599999425 0 0.00059999945 0.001 0.000599999475 0 0.0005999995 0.001 0.000599999525 0 0.00059999955 0.001 0.000599999575 0 0.0005999996 0.001
+ 0.000599999625 0 0.00059999965 0.001 0.000599999675 0 0.0005999997 0.001 0.000599999725 0 0.00059999975 0.001 0.000599999775 0 0.0005999998 0.001
+ 0.000599999825 0 0.00059999985 0.001 0.000599999875 0 0.0005999999 0.001 0.000599999925 0 0.00059999995 0.001 0.000599999975 0 0.0006 0.001
+ 0.000600000025 0 0.00060000005 0.001 0.000600000075 0 0.0006000001 0.001 0.000600000125 0 0.00060000015 0.001 0.000600000175 0 0.0006000002 0.001
+ 0.000600000225 0 0.00060000025 0.001 0.000600000275 0 0.0006000003 0.001 0.000600000325 0 0.00060000035 0.001 0.000600000375 0 0.0006000004 0.001
+ 0.000600000425 0 0.00060000045 0.001 0.000600000475 0 0.0006000005 0.001 0.000600000525 0 0.00060000055 0.001 0.000600000575 0 0.0006000006 0.001
+ 0.000600000625 0 0.00060000065 0.001 0.000600000675 0 0.0006000007 0.001 0.000600000725 0 0.00060000075 0.001 0.000600000775 0 0.0006000008 0.001
+ 0.000600000825 0 0.00060000085 0.001 0.000600000875 0 0.0006000009 0.001 0.000600000925 0 0.00060000095 0.001 0.000600000975 0 0.000600001 0.001
+ 0.000600001025 0 0.00060000105 0.001 0.000600001075 0 0.0006000011 0.001 0.000600001125 0 0.00060000115 0.001 0.000600001175 0 0.0006000012 0.001
+ 0.000600001225 0 0.00060000125 0.001 0.000600001275 0 0.0006000013 0.001 0.000600001325 0 0.00060000135 0.001 0.000600001375 0 0.0006000014 0.001
+ 0.000600001425 0 0.00060000145 0.001 0.000600001475 0 0.0006000015 0.001 0.000600001525 0 0.00060000155 0.001 0.000600001575 0 0.0006000016 0.001
+ 0.000600001625 0 0.00060000165 0.001 0.000600001675 0 0.0006000017 0.001 0.000600001725 0 0.00060000175 0.001 0.000600001775 0 0.0006000018 0.001
+ 0.000600001825 0 0.00060000185 0.001 0.000600001875 0 0.0006000019 0.001 0.000600001925 0 0.00060000195 0.001 0.000600001975 0 0.000600002 0.001
+ 0.000600002025 0 0.00060000205 0.001 0.000600002075 0 0.0006000021 0.001 0.000600002125 0 0.00060000215 0.001 0.000600002175 0 0.0006000022 0.001
+ 0.000600002225 0 0.00060000225 0.001 0.000600002275 0 0.0006000023 0.001 0.000600002325 0 0.00060000235 0.001 0.000600002375 0 0.0006000024 0.001
+ 0.000600002425 0 0.00060000245 0.001 0.000600002475 0 0.0006000025 0.001 0.000600002525 0 0.00060000255 0.001 0.000600002575 0 0.0006000026 0.001
+ 0.000600002625 0 0.00060000265 0.001 0.000600002675 0 0.0006000027 0.001 0.000600002725 0 0.00060000275 0.001 0.000600002775 0 0.0006000028 0.001
+ 0.000600002825 0 0.00060000285 0.001 0.000600002875 0 0.0006000029 0.001 0.000600002925 0 0.00060000295 0.001 0.000600002975 0 0.000600003 0.001
+ 0.000649999 0 0.000649999025 0.001 0.00064999905 0 0.000649999075 0.001 0.0006499991 0 0.000649999125 0.001 0.00064999915 0 0.000649999175 0.001
+ 0.0006499992 0 0.000649999225 0.001 0.00064999925 0 0.000649999275 0.001 0.0006499993 0 0.000649999325 0.001 0.00064999935 0 0.000649999375 0.001
+ 0.0006499994 0 0.000649999425 0.001 0.00064999945 0 0.000649999475 0.001 0.0006499995 0 0.000649999525 0.001 0.00064999955 0 0.000649999575 0.001
+ 0.0006499996 0 0.000649999625 0.001 0.00064999965 0 0.000649999675 0.001 0.0006499997 0 0.000649999725 0.001 0.00064999975 0 0.000649999775 0.001
+ 0.0006499998 0 0.000649999825 0.001 0.00064999985 0 0.000649999875 0.001 0.0006499999 0 0.000649999925 0.001 0.00064999995 0 0.000649999975 0.001
+ 0.00065 0 0.000650000025 0.001 0.00065000005 0 0.000650000075 0.001 0.0006500001 0 0.000650000125 0.001 0.00065000015 0 0.000650000175 0.001
+ 0.0006500002 0 0.000650000225 0.001 0.00065000025 0 0.000650000275 0.001 0.0006500003 0 0.000650000325 0.001 0.00065000035 0 0.000650000375 0.001
+ 0.0006500004 0 0.000650000425 0.001 0.00065000045 0 0.000650000475 0.001 0.0006500005 0 0.000650000525 0.001 0.00065000055 0 0.000650000575 0.001
+ 0.0006500006 0 0.000650000625 0.001 0.00065000065 0 0.000650000675 0.001 0.0006500007 0 0.000650000725 0.001 0.00065000075 0 0.000650000775 0.001
+ 0.0006500008 0 0.000650000825 0.001 0.00065000085 0 0.000650000875 0.001 0.0006500009 0 0.000650000925 0.001 0.00065000095 0 0.000650000975 0.001
+ 0.000650001 0 0.000650001025 0.001 0.00065000105 0 0.000650001075 0.001 0.0006500011 0 0.000650001125 0.001 0.00065000115 0 0.000650001175 0.001
+ 0.0006500012 0 0.000650001225 0.001 0.00065000125 0 0.000650001275 0.001 0.0006500013 0 0.000650001325 0.001 0.00065000135 0 0.000650001375 0.001
+ 0.0006500014 0 0.000650001425 0.001 0.00065000145 0 0.000650001475 0.001 0.0006500015 0 0.000650001525 0.001 0.00065000155 0 0.000650001575 0.001
+ 0.0006500016 0 0.000650001625 0.001 0.00065000165 0 0.000650001675 0.001 0.0006500017 0 0.000650001725 0.001 0.00065000175 0 0.000650001775 0.001
+ 0.0006500018 0 0.000650001825 0.001 0.00065000185 0 0.000650001875 0.001 0.0006500019 0 0.000650001925 0.001 0.00065000195 0 0.000650001975 0.001
+ 0.000650002 0 0.000650002025 0.001 0.00065000205 0 0.000650002075 0.001 0.0006500021 0 0.000650002125 0.001 0.00065000215 0 0.000650002175 0.001
+ 0.0006500022 0 0.000650002225 0.001 0.00065000225 0 0.000650002275 0.001 0.0006500023 0 0.000650002325 0.001 0.00065000235 0 0.000650002375 0.001
+ 0.0006500024 0 0.000650002425 0.001 0.00065000245 0 0.000650002475 0.001 0.0006500025 0 0.000650002525 0.001 0.00065000255 0 0.000650002575 0.001
+ 0.0006500026 0 0.000650002625 0.001 0.00065000265 0 0.000650002675 0.001 0.0006500027 0 0.000650002725 0.001 0.00065000275 0 0.000650002775 0.001
+ 0.0006500028 0 0.000650002825 0.001 0.00065000285 0 0.000650002875 0.001 0.0006500029 0 0.000650002925 0.001 0.00065000295 0 0.000650002975 0.001
+ 0.000650003 0 0.000689999 0.001 0.000689999025 0 0.00068999905 0.001 0.000689999075 0 0.0006899991 0.001 0.000689999125 0 0.00068999915 0.001
+ 0.000689999175 0 0.0006899992 0.001 0.000689999225 0 0.00068999925 0.001 0.000689999275 0 0.0006899993 0.001 0.000689999325 0 0.00068999935 0.001
+ 0.000689999375 0 0.0006899994 0.001 0.000689999425 0 0.00068999945 0.001 0.000689999475 0 0.0006899995 0.001 0.000689999525 0 0.00068999955 0.001
+ 0.000689999575 0 0.0006899996 0.001 0.000689999625 0 0.00068999965 0.001 0.000689999675 0 0.0006899997 0.001 0.000689999725 0 0.00068999975 0.001
+ 0.000689999775 0 0.0006899998 0.001 0.000689999825 0 0.00068999985 0.001 0.000689999875 0 0.0006899999 0.001 0.000689999925 0 0.00068999995 0.001
+ 0.000689999975 0 0.00069 0.001 0.000690000025 0 0.00069000005 0.001 0.000690000075 0 0.0006900001 0.001 0.000690000125 0 0.00069000015 0.001
+ 0.000690000175 0 0.0006900002 0.001 0.000690000225 0 0.00069000025 0.001 0.000690000275 0 0.0006900003 0.001 0.000690000325 0 0.00069000035 0.001
+ 0.000690000375 0 0.0006900004 0.001 0.000690000425 0 0.00069000045 0.001 0.000690000475 0 0.0006900005 0.001 0.000690000525 0 0.00069000055 0.001
+ 0.000690000575 0 0.0006900006 0.001 0.000690000625 0 0.00069000065 0.001 0.000690000675 0 0.0006900007 0.001 0.000690000725 0 0.00069000075 0.001
+ 0.000690000775 0 0.0006900008 0.001 0.000690000825 0 0.00069000085 0.001 0.000690000875 0 0.0006900009 0.001 0.000690000925 0 0.00069000095 0.001
+ 0.000690000975 0 0.000690001 0.001 0.000690001025 0 0.00069000105 0.001 0.000690001075 0 0.0006900011 0.001 0.000690001125 0 0.00069000115 0.001
+ 0.000690001175 0 0.0006900012 0.001 0.000690001225 0 0.00069000125 0.001 0.000690001275 0 0.0006900013 0.001 0.000690001325 0 0.00069000135 0.001
+ 0.000690001375 0 0.0006900014 0.001 0.000690001425 0 0.00069000145 0.001 0.000690001475 0 0.0006900015 0.001 0.000690001525 0 0.00069000155 0.001
+ 0.000690001575 0 0.0006900016 0.001 0.000690001625 0 0.00069000165 0.001 0.000690001675 0 0.0006900017 0.001 0.000690001725 0 0.00069000175 0.001
+ 0.000690001775 0 0.0006900018 0.001 0.000690001825 0 0.00069000185 0.001 0.000690001875 0 0.0006900019 0.001 0.000690001925 0 0.00069000195 0.001
+ 0.000690001975 0 0.000690002 0.001 0.000690002025 0 0.00069000205 0.001 0.000690002075 0 0.0006900021 0.001 0.000690002125 0 0.00069000215 0.001
+ 0.000690002175 0 0.0006900022 0.001 0.000690002225 0 0.00069000225 0.001 0.000690002275 0 0.0006900023 0.001 0.000690002325 0 0.00069000235 0.001
+ 0.000690002375 0 0.0006900024 0.001 0.000690002425 0 0.00069000245 0.001 0.000690002475 0 0.0006900025 0.001 0.000690002525 0 0.00069000255 0.001
+ 0.000690002575 0 0.0006900026 0.001 0.000690002625 0 0.00069000265 0.001 0.000690002675 0 0.0006900027 0.001 0.000690002725 0 0.00069000275 0.001
+ 0.000690002775 0 0.0006900028 0.001 0.000690002825 0 0.00069000285 0.001 0.000690002875 0 0.0006900029 0.001 0.000690002925 0 0.00069000295 0.001
+ 0.000690002975 0 0.000690003 0.001 0.000699999 0 0.000699999025 0.001 0.00069999905 0 0.000699999075 0.001 0.0006999991 0 0.000699999125 0.001
+ 0.00069999915 0 0.000699999175 0.001 0.0006999992 0 0.000699999225 0.001 0.00069999925 0 0.000699999275 0.001 0.0006999993 0 0.000699999325 0.001
+ 0.00069999935 0 0.000699999375 0.001 0.0006999994 0 0.000699999425 0.001 0.00069999945 0 0.000699999475 0.001 0.0006999995 0 0.000699999525 0.001
+ 0.00069999955 0 0.000699999575 0.001 0.0006999996 0 0.000699999625 0.001 0.00069999965 0 0.000699999675 0.001 0.0006999997 0 0.000699999725 0.001
+ 0.00069999975 0 0.000699999775 0.001 0.0006999998 0 0.000699999825 0.001 0.00069999985 0 0.000699999875 0.001 0.0006999999 0 0.000699999925 0.001
+ 0.00069999995 0 0.000699999975 0.001 0.0007 0 0.000700000025 0.001 0.00070000005 0 0.000700000075 0.001 0.0007000001 0 0.000700000125 0.001
+ 0.00070000015 0 0.000700000175 0.001 0.0007000002 0 0.000700000225 0.001 0.00070000025 0 0.000700000275 0.001 0.0007000003 0 0.000700000325 0.001
+ 0.00070000035 0 0.000700000375 0.001 0.0007000004 0 0.000700000425 0.001 0.00070000045 0 0.000700000475 0.001 0.0007000005 0 0.000700000525 0.001
+ 0.00070000055 0 0.000700000575 0.001 0.0007000006 0 0.000700000625 0.001 0.00070000065 0 0.000700000675 0.001 0.0007000007 0 0.000700000725 0.001
+ 0.00070000075 0 0.000700000775 0.001 0.0007000008 0 0.000700000825 0.001 0.00070000085 0 0.000700000875 0.001 0.0007000009 0 0.000700000925 0.001
+ 0.00070000095 0 0.000700000975 0.001 0.000700001 0 0.000700001025 0.001 0.00070000105 0 0.000700001075 0.001 0.0007000011 0 0.000700001125 0.001
+ 0.00070000115 0 0.000700001175 0.001 0.0007000012 0 0.000700001225 0.001 0.00070000125 0 0.000700001275 0.001 0.0007000013 0 0.000700001325 0.001
+ 0.00070000135 0 0.000700001375 0.001 0.0007000014 0 0.000700001425 0.001 0.00070000145 0 0.000700001475 0.001 0.0007000015 0 0.000700001525 0.001
+ 0.00070000155 0 0.000700001575 0.001 0.0007000016 0 0.000700001625 0.001 0.00070000165 0 0.000700001675 0.001 0.0007000017 0 0.000700001725 0.001
+ 0.00070000175 0 0.000700001775 0.001 0.0007000018 0 0.000700001825 0.001 0.00070000185 0 0.000700001875 0.001 0.0007000019 0 0.000700001925 0.001
+ 0.00070000195 0 0.000700001975 0.001 0.000700002 0 0.000700002025 0.001 0.00070000205 0 0.000700002075 0.001 0.0007000021 0 0.000700002125 0.001
+ 0.00070000215 0 0.000700002175 0.001 0.0007000022 0 0.000700002225 0.001 0.00070000225 0 0.000700002275 0.001 0.0007000023 0 0.000700002325 0.001
+ 0.00070000235 0 0.000700002375 0.001 0.0007000024 0 0.000700002425 0.001 0.00070000245 0 0.000700002475 0.001 0.0007000025 0 0.000700002525 0.001
+ 0.00070000255 0 0.000700002575 0.001 0.0007000026 0 0.000700002625 0.001 0.00070000265 0 0.000700002675 0.001 0.0007000027 0 0.000700002725 0.001
+ 0.00070000275 0 0.000700002775 0.001 0.0007000028 0 0.000700002825 0.001 0.00070000285 0 0.000700002875 0.001 0.0007000029 0 0.000700002925 0.001
+ 0.00070000295 0 0.000700002975 0.001 0.000700003 0 0.000749899 0.001 0.000749899025 0 0.00074989905 0.001 0.000749899075 0 0.0007498991 0.001
+ 0.000749899125 0 0.00074989915 0.001 0.000749899175 0 0.0007498992 0.001 0.000749899225 0 0.00074989925 0.001 0.000749899275 0 0.0007498993 0.001
+ 0.000749899325 0 0.00074989935 0.001 0.000749899375 0 0.0007498994 0.001 0.000749899425 0 0.00074989945 0.001 0.000749899475 0 0.0007498995 0.001
+ 0.000749899525 0 0.00074989955 0.001 0.000749899575 0 0.0007498996 0.001 0.000749899625 0 0.00074989965 0.001 0.000749899675 0 0.0007498997 0.001
+ 0.000749899725 0 0.00074989975 0.001 0.000749899775 0 0.0007498998 0.001 0.000749899825 0 0.00074989985 0.001 0.000749899875 0 0.0007498999 0.001
+ 0.000749899925 0 0.00074989995 0.001 0.000749899975 0 0.0007499 0.001 0.000749900025 0 0.00074990005 0.001 0.000749900075 0 0.0007499001 0.001
+ 0.000749900125 0 0.00074990015 0.001 0.000749900175 0 0.0007499002 0.001 0.000749900225 0 0.00074990025 0.001 0.000749900275 0 0.0007499003 0.001
+ 0.000749900325 0 0.00074990035 0.001 0.000749900375 0 0.0007499004 0.001 0.000749900425 0 0.00074990045 0.001 0.000749900475 0 0.0007499005 0.001
+ 0.000749900525 0 0.00074990055 0.001 0.000749900575 0 0.0007499006 0.001 0.000749900625 0 0.00074990065 0.001 0.000749900675 0 0.0007499007 0.001
+ 0.000749900725 0 0.00074990075 0.001 0.000749900775 0 0.0007499008 0.001 0.000749900825 0 0.00074990085 0.001 0.000749900875 0 0.0007499009 0.001
+ 0.000749900925 0 0.00074990095 0.001 0.000749900975 0 0.000749901 0.001 0.000749901025 0 0.00074990105 0.001 0.000749901075 0 0.0007499011 0.001
+ 0.000749901125 0 0.00074990115 0.001 0.000749901175 0 0.0007499012 0.001 0.000749901225 0 0.00074990125 0.001 0.000749901275 0 0.0007499013 0.001
+ 0.000749901325 0 0.00074990135 0.001 0.000749901375 0 0.0007499014 0.001 0.000749901425 0 0.00074990145 0.001 0.000749901475 0 0.0007499015 0.001
+ 0.000749901525 0 0.00074990155 0.001 0.000749901575 0 0.0007499016 0.001 0.000749901625 0 0.00074990165 0.001 0.000749901675 0 0.0007499017 0.001
+ 0.000749901725 0 0.00074990175 0.001 0.000749901775 0 0.0007499018 0.001 0.000749901825 0 0.00074990185 0.001 0.000749901875 0 0.0007499019 0.001
+ 0.000749901925 0 0.00074990195 0.001 0.000749901975 0 0.000749902 0.001 0.000749902025 0 0.00074990205 0.001 0.000749902075 0 0.0007499021 0.001
+ 0.000749902125 0 0.00074990215 0.001 0.000749902175 0 0.0007499022 0.001 0.000749902225 0 0.00074990225 0.001 0.000749902275 0 0.0007499023 0.001
+ 0.000749902325 0 0.00074990235 0.001 0.000749902375 0 0.0007499024 0.001 0.000749902425 0 0.00074990245 0.001 0.000749902475 0 0.0007499025 0.001
+ 0.000749902525 0 0.00074990255 0.001 0.000749902575 0 0.0007499026 0.001 0.000749902625 0 0.00074990265 0.001 0.000749902675 0 0.0007499027 0.001
+ 0.000749902725 0 0.00074990275 0.001 0.000749902775 0 0.0007499028 0.001 0.000749902825 0 0.00074990285 0.001 0.000749902875 0 0.0007499029 0.001
+ 0.000749902925 0 0.00074990295 0.001 0.000749902975 0 0.000749903 0.001 0.000749999 0 0.000749999025 0.001 0.00074999905 0 0.000749999075 0.001
+ 0.0007499991 0 0.000749999125 0.001 0.00074999915 0 0.000749999175 0.001 0.0007499992 0 0.000749999225 0.001 0.00074999925 0 0.000749999275 0.001
+ 0.0007499993 0 0.000749999325 0.001 0.00074999935 0 0.000749999375 0.001 0.0007499994 0 0.000749999425 0.001 0.00074999945 0 0.000749999475 0.001
+ 0.0007499995 0 0.000749999525 0.001 0.00074999955 0 0.000749999575 0.001 0.0007499996 0 0.000749999625 0.001 0.00074999965 0 0.000749999675 0.001
+ 0.0007499997 0 0.000749999725 0.001 0.00074999975 0 0.000749999775 0.001 0.0007499998 0 0.000749999825 0.001 0.00074999985 0 0.000749999875 0.001
+ 0.0007499999 0 0.000749999925 0.001 0.00074999995 0 0.000749999975 0.001 0.00075 0 0.000750000025 0.001 0.00075000005 0 0.000750000075 0.001
+ 0.0007500001 0 0.000750000125 0.001 0.00075000015 0 0.000750000175 0.001 0.0007500002 0 0.000750000225 0.001 0.00075000025 0 0.000750000275 0.001
+ 0.0007500003 0 0.000750000325 0.001 0.00075000035 0 0.000750000375 0.001 0.0007500004 0 0.000750000425 0.001 0.00075000045 0 0.000750000475 0.001
+ 0.0007500005 0 0.000750000525 0.001 0.00075000055 0 0.000750000575 0.001 0.0007500006 0 0.000750000625 0.001 0.00075000065 0 0.000750000675 0.001
+ 0.0007500007 0 0.000750000725 0.001 0.00075000075 0 0.000750000775 0.001 0.0007500008 0 0.000750000825 0.001 0.00075000085 0 0.000750000875 0.001
+ 0.0007500009 0 0.000750000925 0.001 0.00075000095 0 0.000750000975 0.001 0.000750001 0 0.000750001025 0.001 0.00075000105 0 0.000750001075 0.001
+ 0.0007500011 0 0.000750001125 0.001 0.00075000115 0 0.000750001175 0.001 0.0007500012 0 0.000750001225 0.001 0.00075000125 0 0.000750001275 0.001
+ 0.0007500013 0 0.000750001325 0.001 0.00075000135 0 0.000750001375 0.001 0.0007500014 0 0.000750001425 0.001 0.00075000145 0 0.000750001475 0.001
+ 0.0007500015 0 0.000750001525 0.001 0.00075000155 0 0.000750001575 0.001 0.0007500016 0 0.000750001625 0.001 0.00075000165 0 0.000750001675 0.001
+ 0.0007500017 0 0.000750001725 0.001 0.00075000175 0 0.000750001775 0.001 0.0007500018 0 0.000750001825 0.001 0.00075000185 0 0.000750001875 0.001
+ 0.0007500019 0 0.000750001925 0.001 0.00075000195 0 0.000750001975 0.001 0.000750002 0 0.000750002025 0.001 0.00075000205 0 0.000750002075 0.001
+ 0.0007500021 0 0.000750002125 0.001 0.00075000215 0 0.000750002175 0.001 0.0007500022 0 0.000750002225 0.001 0.00075000225 0 0.000750002275 0.001
+ 0.0007500023 0 0.000750002325 0.001 0.00075000235 0 0.000750002375 0.001 0.0007500024 0 0.000750002425 0.001 0.00075000245 0 0.000750002475 0.001
+ 0.0007500025 0 0.000750002525 0.001 0.00075000255 0 0.000750002575 0.001 0.0007500026 0 0.000750002625 0.001 0.00075000265 0 0.000750002675 0.001
+ 0.0007500027 0 0.000750002725 0.001 0.00075000275 0 0.000750002775 0.001 0.0007500028 0 0.000750002825 0.001 0.00075000285 0 0.000750002875 0.001
+ 0.0007500029 0 0.000750002925 0.001 0.00075000295 0 0.000750002975 0.001 0.000750003 0 0.000799999 0.001 0.000799999025 0 0.00079999905 0.001
+ 0.000799999075 0 0.0007999991 0.001 0.000799999125 0 0.00079999915 0.001 0.000799999175 0 0.0007999992 0.001 0.000799999225 0 0.00079999925 0.001
+ 0.000799999275 0 0.0007999993 0.001 0.000799999325 0 0.00079999935 0.001 0.000799999375 0 0.0007999994 0.001 0.000799999425 0 0.00079999945 0.001
+ 0.000799999475 0 0.0007999995 0.001 0.000799999525 0 0.00079999955 0.001 0.000799999575 0 0.0007999996 0.001 0.000799999625 0 0.00079999965 0.001
+ 0.000799999675 0 0.0007999997 0.001 0.000799999725 0 0.00079999975 0.001 0.000799999775 0 0.0007999998 0.001 0.000799999825 0 0.00079999985 0.001
+ 0.000799999875 0 0.0007999999 0.001 0.000799999925 0 0.00079999995 0.001 0.000799999975 0 0.0008 0.001 0.000800000025 0 0.00080000005 0.001
+ 0.000800000075 0 0.0008000001 0.001 0.000800000125 0 0.00080000015 0.001 0.000800000175 0 0.0008000002 0.001 0.000800000225 0 0.00080000025 0.001
+ 0.000800000275 0 0.0008000003 0.001 0.000800000325 0 0.00080000035 0.001 0.000800000375 0 0.0008000004 0.001 0.000800000425 0 0.00080000045 0.001
+ 0.000800000475 0 0.0008000005 0.001 0.000800000525 0 0.00080000055 0.001 0.000800000575 0 0.0008000006 0.001 0.000800000625 0 0.00080000065 0.001
+ 0.000800000675 0 0.0008000007 0.001 0.000800000725 0 0.00080000075 0.001 0.000800000775 0 0.0008000008 0.001 0.000800000825 0 0.00080000085 0.001
+ 0.000800000875 0 0.0008000009 0.001 0.000800000925 0 0.00080000095 0.001 0.000800000975 0 0.000800001 0.001 0.000800001025 0 0.00080000105 0.001
+ 0.000800001075 0 0.0008000011 0.001 0.000800001125 0 0.00080000115 0.001 0.000800001175 0 0.0008000012 0.001 0.000800001225 0 0.00080000125 0.001
+ 0.000800001275 0 0.0008000013 0.001 0.000800001325 0 0.00080000135 0.001 0.000800001375 0 0.0008000014 0.001 0.000800001425 0 0.00080000145 0.001
+ 0.000800001475 0 0.0008000015 0.001 0.000800001525 0 0.00080000155 0.001 0.000800001575 0 0.0008000016 0.001 0.000800001625 0 0.00080000165 0.001
+ 0.000800001675 0 0.0008000017 0.001 0.000800001725 0 0.00080000175 0.001 0.000800001775 0 0.0008000018 0.001 0.000800001825 0 0.00080000185 0.001
+ 0.000800001875 0 0.0008000019 0.001 0.000800001925 0 0.00080000195 0.001 0.000800001975 0 0.000800002 0.001 0.000800002025 0 0.00080000205 0.001
+ 0.000800002075 0 0.0008000021 0.001 0.000800002125 0 0.00080000215 0.001 0.000800002175 0 0.0008000022 0.001 0.000800002225 0 0.00080000225 0.001
+ 0.000800002275 0 0.0008000023 0.001 0.000800002325 0 0.00080000235 0.001 0.000800002375 0 0.0008000024 0.001 0.000800002425 0 0.00080000245 0.001
+ 0.000800002475 0 0.0008000025 0.001 0.000800002525 0 0.00080000255 0.001 0.000800002575 0 0.0008000026 0.001 0.000800002625 0 0.00080000265 0.001
+ 0.000800002675 0 0.0008000027 0.001 0.000800002725 0 0.00080000275 0.001 0.000800002775 0 0.0008000028 0.001 0.000800002825 0 0.00080000285 0.001
+ 0.000800002875 0 0.0008000029 0.001 0.000800002925 0 0.00080000295 0.001 0.000800002975 0 0.000800003 0.001 0.000849999 0 0.000849999025 0.001
+ 0.00084999905 0 0.000849999075 0.001 0.0008499991 0 0.000849999125 0.001 0.00084999915 0 0.000849999175 0.001 0.0008499992 0 0.000849999225 0.001
+ 0.00084999925 0 0.000849999275 0.001 0.0008499993 0 0.000849999325 0.001 0.00084999935 0 0.000849999375 0.001 0.0008499994 0 0.000849999425 0.001
+ 0.00084999945 0 0.000849999475 0.001 0.0008499995 0 0.000849999525 0.001 0.00084999955 0 0.000849999575 0.001 0.0008499996 0 0.000849999625 0.001
+ 0.00084999965 0 0.000849999675 0.001 0.0008499997 0 0.000849999725 0.001 0.00084999975 0 0.000849999775 0.001 0.0008499998 0 0.000849999825 0.001
+ 0.00084999985 0 0.000849999875 0.001 0.0008499999 0 0.000849999925 0.001 0.00084999995 0 0.000849999975 0.001 0.00085 0 0.000850000025 0.001
+ 0.00085000005 0 0.000850000075 0.001 0.0008500001 0 0.000850000125 0.001 0.00085000015 0 0.000850000175 0.001 0.0008500002 0 0.000850000225 0.001
+ 0.00085000025 0 0.000850000275 0.001 0.0008500003 0 0.000850000325 0.001 0.00085000035 0 0.000850000375 0.001 0.0008500004 0 0.000850000425 0.001
+ 0.00085000045 0 0.000850000475 0.001 0.0008500005 0 0.000850000525 0.001 0.00085000055 0 0.000850000575 0.001 0.0008500006 0 0.000850000625 0.001
+ 0.00085000065 0 0.000850000675 0.001 0.0008500007 0 0.000850000725 0.001 0.00085000075 0 0.000850000775 0.001 0.0008500008 0 0.000850000825 0.001
+ 0.00085000085 0 0.000850000875 0.001 0.0008500009 0 0.000850000925 0.001 0.00085000095 0 0.000850000975 0.001 0.000850001 0 0.000850001025 0.001
+ 0.00085000105 0 0.000850001075 0.001 0.0008500011 0 0.000850001125 0.001 0.00085000115 0 0.000850001175 0.001 0.0008500012 0 0.000850001225 0.001
+ 0.00085000125 0 0.000850001275 0.001 0.0008500013 0 0.000850001325 0.001 0.00085000135 0 0.000850001375 0.001 0.0008500014 0 0.000850001425 0.001
+ 0.00085000145 0 0.000850001475 0.001 0.0008500015 0 0.000850001525 0.001 0.00085000155 0 0.000850001575 0.001 0.0008500016 0 0.000850001625 0.001
+ 0.00085000165 0 0.000850001675 0.001 0.0008500017 0 0.000850001725 0.001 0.00085000175 0 0.000850001775 0.001 0.0008500018 0 0.000850001825 0.001
+ 0.00085000185 0 0.000850001875 0.001 0.0008500019 0 0.000850001925 0.001 0.00085000195 0 0.000850001975 0.001 0.000850002 0 0.000850002025 0.001
+ 0.00085000205 0 0.000850002075 0.001 0.0008500021 0 0.000850002125 0.001 0.00085000215 0 0.000850002175 0.001 0.0008500022 0 0.000850002225 0.001
+ 0.00085000225 0 0.000850002275 0.001 0.0008500023 0 0.000850002325 0.001 0.00085000235 0 0.000850002375 0.001 0.0008500024 0 0.000850002425 0.001
+ 0.00085000245 0 0.000850002475 0.001 0.0008500025 0 0.000850002525 0.001 0.00085000255 0 0.000850002575 0.001 0.0008500026 0 0.000850002625 0.001
+ 0.00085000265 0 0.000850002675 0.001 0.0008500027 0 0.000850002725 0.001 0.00085000275 0 0.000850002775 0.001 0.0008500028 0 0.000850002825 0.001
+ 0.00085000285 0 0.000850002875 0.001 0.0008500029 0 0.000850002925 0.001 0.00085000295 0 0.000850002975 0.001 0.000850003 0 0.000899999 0.001
+ 0.000899999025 0 0.00089999905 0.001 0.000899999075 0 0.0008999991 0.001 0.000899999125 0 0.00089999915 0.001 0.000899999175 0 0.0008999992 0.001
+ 0.000899999225 0 0.00089999925 0.001 0.000899999275 0 0.0008999993 0.001 0.000899999325 0 0.00089999935 0.001 0.000899999375 0 0.0008999994 0.001
+ 0.000899999425 0 0.00089999945 0.001 0.000899999475 0 0.0008999995 0.001 0.000899999525 0 0.00089999955 0.001 0.000899999575 0 0.0008999996 0.001
+ 0.000899999625 0 0.00089999965 0.001 0.000899999675 0 0.0008999997 0.001 0.000899999725 0 0.00089999975 0.001 0.000899999775 0 0.0008999998 0.001
+ 0.000899999825 0 0.00089999985 0.001 0.000899999875 0 0.0008999999 0.001 0.000899999925 0 0.00089999995 0.001 0.000899999975 0 0.0009 0.001
+ 0.000900000025 0 0.00090000005 0.001 0.000900000075 0 0.0009000001 0.001 0.000900000125 0 0.00090000015 0.001 0.000900000175 0 0.0009000002 0.001
+ 0.000900000225 0 0.00090000025 0.001 0.000900000275 0 0.0009000003 0.001 0.000900000325 0 0.00090000035 0.001 0.000900000375 0 0.0009000004 0.001
+ 0.000900000425 0 0.00090000045 0.001 0.000900000475 0 0.0009000005 0.001 0.000900000525 0 0.00090000055 0.001 0.000900000575 0 0.0009000006 0.001
+ 0.000900000625 0 0.00090000065 0.001 0.000900000675 0 0.0009000007 0.001 0.000900000725 0 0.00090000075 0.001 0.000900000775 0 0.0009000008 0.001
+ 0.000900000825 0 0.00090000085 0.001 0.000900000875 0 0.0009000009 0.001 0.000900000925 0 0.00090000095 0.001 0.000900000975 0 0.000900001 0.001
+ 0.000900001025 0 0.00090000105 0.001 0.000900001075 0 0.0009000011 0.001 0.000900001125 0 0.00090000115 0.001 0.000900001175 0 0.0009000012 0.001
+ 0.000900001225 0 0.00090000125 0.001 0.000900001275 0 0.0009000013 0.001 0.000900001325 0 0.00090000135 0.001 0.000900001375 0 0.0009000014 0.001
+ 0.000900001425 0 0.00090000145 0.001 0.000900001475 0 0.0009000015 0.001 0.000900001525 0 0.00090000155 0.001 0.000900001575 0 0.0009000016 0.001
+ 0.000900001625 0 0.00090000165 0.001 0.000900001675 0 0.0009000017 0.001 0.000900001725 0 0.00090000175 0.001 0.000900001775 0 0.0009000018 0.001
+ 0.000900001825 0 0.00090000185 0.001 0.000900001875 0 0.0009000019 0.001 0.000900001925 0 0.00090000195 0.001 0.000900001975 0 0.000900002 0.001
+ 0.000900002025 0 0.00090000205 0.001 0.000900002075 0 0.0009000021 0.001 0.000900002125 0 0.00090000215 0.001 0.000900002175 0 0.0009000022 0.001
+ 0.000900002225 0 0.00090000225 0.001 0.000900002275 0 0.0009000023 0.001 0.000900002325 0 0.00090000235 0.001 0.000900002375 0 0.0009000024 0.001
+ 0.000900002425 0 0.00090000245 0.001 0.000900002475 0 0.0009000025 0.001 0.000900002525 0 0.00090000255 0.001 0.000900002575 0 0.0009000026 0.001
+ 0.000900002625 0 0.00090000265 0.001 0.000900002675 0 0.0009000027 0.001 0.000900002725 0 0.00090000275 0.001 0.000900002775 0 0.0009000028 0.001
+ 0.000900002825 0 0.00090000285 0.001 0.000900002875 0 0.0009000029 0.001 0.000900002925 0 0.00090000295 0.001 0.000900002975 0 0.000900003 0.001
+ 0.000949999 0 0.000949999025 0.001 0.00094999905 0 0.000949999075 0.001 0.0009499991 0 0.000949999125 0.001 0.00094999915 0 0.000949999175 0.001
+ 0.0009499992 0 0.000949999225 0.001 0.00094999925 0 0.000949999275 0.001 0.0009499993 0 0.000949999325 0.001 0.00094999935 0 0.000949999375 0.001
+ 0.0009499994 0 0.000949999425 0.001 0.00094999945 0 0.000949999475 0.001 0.0009499995 0 0.000949999525 0.001 0.00094999955 0 0.000949999575 0.001
+ 0.0009499996 0 0.000949999625 0.001 0.00094999965 0 0.000949999675 0.001 0.0009499997 0 0.000949999725 0.001 0.00094999975 0 0.000949999775 0.001
+ 0.0009499998 0 0.000949999825 0.001 0.00094999985 0 0.000949999875 0.001 0.0009499999 0 0.000949999925 0.001 0.00094999995 0 0.000949999975 0.001
+ 0.00095 0 0.000950000025 0.001 0.00095000005 0 0.000950000075 0.001 0.0009500001 0 0.000950000125 0.001 0.00095000015 0 0.000950000175 0.001
+ 0.0009500002 0 0.000950000225 0.001 0.00095000025 0 0.000950000275 0.001 0.0009500003 0 0.000950000325 0.001 0.00095000035 0 0.000950000375 0.001
+ 0.0009500004 0 0.000950000425 0.001 0.00095000045 0 0.000950000475 0.001 0.0009500005 0 0.000950000525 0.001 0.00095000055 0 0.000950000575 0.001
+ 0.0009500006 0 0.000950000625 0.001 0.00095000065 0 0.000950000675 0.001 0.0009500007 0 0.000950000725 0.001 0.00095000075 0 0.000950000775 0.001
+ 0.0009500008 0 0.000950000825 0.001 0.00095000085 0 0.000950000875 0.001 0.0009500009 0 0.000950000925 0.001 0.00095000095 0 0.000950000975 0.001
+ 0.000950001 0 0.000950001025 0.001 0.00095000105 0 0.000950001075 0.001 0.0009500011 0 0.000950001125 0.001 0.00095000115 0 0.000950001175 0.001
+ 0.0009500012 0 0.000950001225 0.001 0.00095000125 0 0.000950001275 0.001 0.0009500013 0 0.000950001325 0.001 0.00095000135 0 0.000950001375 0.001
+ 0.0009500014 0 0.000950001425 0.001 0.00095000145 0 0.000950001475 0.001 0.0009500015 0 0.000950001525 0.001 0.00095000155 0 0.000950001575 0.001
+ 0.0009500016 0 0.000950001625 0.001 0.00095000165 0 0.000950001675 0.001 0.0009500017 0 0.000950001725 0.001 0.00095000175 0 0.000950001775 0.001
+ 0.0009500018 0 0.000950001825 0.001 0.00095000185 0 0.000950001875 0.001 0.0009500019 0 0.000950001925 0.001 0.00095000195 0 0.000950001975 0.001
+ 0.000950002 0 0.000950002025 0.001 0.00095000205 0 0.000950002075 0.001 0.0009500021 0 0.000950002125 0.001 0.00095000215 0 0.000950002175 0.001
+ 0.0009500022 0 0.000950002225 0.001 0.00095000225 0 0.000950002275 0.001 0.0009500023 0 0.000950002325 0.001 0.00095000235 0 0.000950002375 0.001
+ 0.0009500024 0 0.000950002425 0.001 0.00095000245 0 0.000950002475 0.001 0.0009500025 0 0.000950002525 0.001 0.00095000255 0 0.000950002575 0.001
+ 0.0009500026 0 0.000950002625 0.001 0.00095000265 0 0.000950002675 0.001 0.0009500027 0 0.000950002725 0.001 0.00095000275 0 0.000950002775 0.001
+ 0.0009500028 0 0.000950002825 0.001 0.00095000285 0 0.000950002875 0.001 0.0009500029 0 0.000950002925 0.001 0.00095000295 0 0.000950002975 0.001
+ 0.000950003 0 0.000989999 0.001 0.000989999025 0 0.00098999905 0.001 0.000989999075 0 0.0009899991 0.001 0.000989999125 0 0.00098999915 0.001
+ 0.000989999175 0 0.0009899992 0.001 0.000989999225 0 0.00098999925 0.001 0.000989999275 0 0.0009899993 0.001 0.000989999325 0 0.00098999935 0.001
+ 0.000989999375 0 0.0009899994 0.001 0.000989999425 0 0.00098999945 0.001 0.000989999475 0 0.0009899995 0.001 0.000989999525 0 0.00098999955 0.001
+ 0.000989999575 0 0.0009899996 0.001 0.000989999625 0 0.00098999965 0.001 0.000989999675 0 0.0009899997 0.001 0.000989999725 0 0.00098999975 0.001
+ 0.000989999775 0 0.0009899998 0.001 0.000989999825 0 0.00098999985 0.001 0.000989999875 0 0.0009899999 0.001 0.000989999925 0 0.00098999995 0.001
+ 0.000989999975 0 0.00099 0.001 0.000990000025 0 0.00099000005 0.001 0.000990000075 0 0.0009900001 0.001 0.000990000125 0 0.00099000015 0.001
+ 0.000990000175 0 0.0009900002 0.001 0.000990000225 0 0.00099000025 0.001 0.000990000275 0 0.0009900003 0.001 0.000990000325 0 0.00099000035 0.001
+ 0.000990000375 0 0.0009900004 0.001 0.000990000425 0 0.00099000045 0.001 0.000990000475 0 0.0009900005 0.001 0.000990000525 0 0.00099000055 0.001
+ 0.000990000575 0 0.0009900006 0.001 0.000990000625 0 0.00099000065 0.001 0.000990000675 0 0.0009900007 0.001 0.000990000725 0 0.00099000075 0.001
+ 0.000990000775 0 0.0009900008 0.001 0.000990000825 0 0.00099000085 0.001 0.000990000875 0 0.0009900009 0.001 0.000990000925 0 0.00099000095 0.001
+ 0.000990000975 0 0.000990001 0.001 0.000990001025 0 0.00099000105 0.001 0.000990001075 0 0.0009900011 0.001 0.000990001125 0 0.00099000115 0.001
+ 0.000990001175 0 0.0009900012 0.001 0.000990001225 0 0.00099000125 0.001 0.000990001275 0 0.0009900013 0.001 0.000990001325 0 0.00099000135 0.001
+ 0.000990001375 0 0.0009900014 0.001 0.000990001425 0 0.00099000145 0.001 0.000990001475 0 0.0009900015 0.001 0.000990001525 0 0.00099000155 0.001
+ 0.000990001575 0 0.0009900016 0.001 0.000990001625 0 0.00099000165 0.001 0.000990001675 0 0.0009900017 0.001 0.000990001725 0 0.00099000175 0.001
+ 0.000990001775 0 0.0009900018 0.001 0.000990001825 0 0.00099000185 0.001 0.000990001875 0 0.0009900019 0.001 0.000990001925 0 0.00099000195 0.001
+ 0.000990001975 0 0.000990002 0.001 0.000990002025 0 0.00099000205 0.001 0.000990002075 0 0.0009900021 0.001 0.000990002125 0 0.00099000215 0.001
+ 0.000990002175 0 0.0009900022 0.001 0.000990002225 0 0.00099000225 0.001 0.000990002275 0 0.0009900023 0.001 0.000990002325 0 0.00099000235 0.001
+ 0.000990002375 0 0.0009900024 0.001 0.000990002425 0 0.00099000245 0.001 0.000990002475 0 0.0009900025 0.001 0.000990002525 0 0.00099000255 0.001
+ 0.000990002575 0 0.0009900026 0.001 0.000990002625 0 0.00099000265 0.001 0.000990002675 0 0.0009900027 0.001 0.000990002725 0 0.00099000275 0.001
+ 0.000990002775 0 0.0009900028 0.001 0.000990002825 0 0.00099000285 0.001 0.000990002875 0 0.0009900029 0.001 0.000990002925 0 0.00099000295 0.001
+ 0.000990002975 0 0.000990003 0.001 0.000999999 0 0.000999999025 0.001 0.00099999905 0 0.000999999075 0.001 0.0009999991 0 0.000999999125 0.001
+ 0.00099999915 0 0.000999999175 0.001 0.0009999992 0 0.000999999225 0.001 0.00099999925 0 0.000999999275 0.001 0.0009999993 0 0.000999999325 0.001
+ 0.00099999935 0 0.000999999375 0.001 0.0009999994 0 0.000999999425 0.001 0.00099999945 0 0.000999999475 0.001 0.0009999995 0 0.000999999525 0.001
+ 0.00099999955 0 0.000999999575 0.001 0.0009999996 0 0.000999999625 0.001 0.00099999965 0 0.000999999675 0.001 0.0009999997 0 0.000999999725 0.001
+ 0.00099999975 0 0.000999999775 0.001 0.0009999998 0 0.000999999825 0.001 0.00099999985 0 0.000999999875 0.001 0.0009999999 0 0.000999999925 0.001
+ 0.00099999995 0 0.000999999975 0.001 0.001 0 0.001000000025 0.001 0.00100000005 0 0.001000000075 0.001 0.0010000001 0 0.001000000125 0.001
+ 0.00100000015 0 0.001000000175 0.001 0.0010000002 0 0.001000000225 0.001 0.00100000025 0 0.001000000275 0.001 0.0010000003 0 0.001000000325 0.001
+ 0.00100000035 0 0.001000000375 0.001 0.0010000004 0 0.001000000425 0.001 0.00100000045 0 0.001000000475 0.001 0.0010000005 0 0.001000000525 0.001
+ 0.00100000055 0 0.001000000575 0.001 0.0010000006 0 0.001000000625 0.001 0.00100000065 0 0.001000000675 0.001 0.0010000007 0 0.001000000725 0.001
+ 0.00100000075 0 0.001000000775 0.001 0.0010000008 0 0.001000000825 0.001 0.00100000085 0 0.001000000875 0.001 0.0010000009 0 0.001000000925 0.001
+ 0.00100000095 0 0.001000000975 0.001 0.001000001 0 0.001000001025 0.001 0.00100000105 0 0.001000001075 0.001 0.0010000011 0 0.001000001125 0.001
+ 0.00100000115 0 0.001000001175 0.001 0.0010000012 0 0.001000001225 0.001 0.00100000125 0 0.001000001275 0.001 0.0010000013 0 0.001000001325 0.001
+ 0.00100000135 0 0.001000001375 0.001 0.0010000014 0 0.001000001425 0.001 0.00100000145 0 0.001000001475 0.001 0.0010000015 0 0.001000001525 0.001
+ 0.00100000155 0 0.001000001575 0.001 0.0010000016 0 0.001000001625 0.001 0.00100000165 0 0.001000001675 0.001 0.0010000017 0 0.001000001725 0.001
+ 0.00100000175 0 0.001000001775 0.001 0.0010000018 0 0.001000001825 0.001 0.00100000185 0 0.001000001875 0.001 0.0010000019 0 0.001000001925 0.001
+ 0.00100000195 0 0.001000001975 0.001 0.001000002 0 0.001000002025 0.001 0.00100000205 0 0.001000002075 0.001 0.0010000021 0 0.001000002125 0.001
+ 0.00100000215 0 0.001000002175 0.001 0.0010000022 0 0.001000002225 0.001 0.00100000225 0 0.001000002275 0.001 0.0010000023 0 0.001000002325 0.001
+ 0.00100000235 0 0.001000002375 0.001 0.0010000024 0 0.001000002425 0.001 0.00100000245 0 0.001000002475 0.001 0.0010000025 0 0.001000002525 0.001
+ 0.00100000255 0 0.001000002575 0.001 0.0010000026 0 0.001000002625 0.001 0.00100000265 0 0.001000002675 0.001 0.0010000027 0 0.001000002725 0.001
+ 0.00100000275 0 0.001000002775 0.001 0.0010000028 0 0.001000002825 0.001 0.00100000285 0 0.001000002875 0.001 0.0010000029 0 0.001000002925 0.001
+ 0.00100000295 0 0.001000002975 0.001 0.001000003 0 0.001049989 0.001 0.001049989025 0 0.00104998905 0.001 0.001049989075 0 0.0010499891 0.001
+ 0.001049989125 0 0.00104998915 0.001 0.001049989175 0 0.0010499892 0.001 0.001049989225 0 0.00104998925 0.001 0.001049989275 0 0.0010499893 0.001
+ 0.001049989325 0 0.00104998935 0.001 0.001049989375 0 0.0010499894 0.001 0.001049989425 0 0.00104998945 0.001 0.001049989475 0 0.0010499895 0.001
+ 0.001049989525 0 0.00104998955 0.001 0.001049989575 0 0.0010499896 0.001 0.001049989625 0 0.00104998965 0.001 0.001049989675 0 0.0010499897 0.001
+ 0.001049989725 0 0.00104998975 0.001 0.001049989775 0 0.0010499898 0.001 0.001049989825 0 0.00104998985 0.001 0.001049989875 0 0.0010499899 0.001
+ 0.001049989925 0 0.00104998995 0.001 0.001049989975 0 0.00104999 0.001 0.001049990025 0 0.00104999005 0.001 0.001049990075 0 0.0010499901 0.001
+ 0.001049990125 0 0.00104999015 0.001 0.001049990175 0 0.0010499902 0.001 0.001049990225 0 0.00104999025 0.001 0.001049990275 0 0.0010499903 0.001
+ 0.001049990325 0 0.00104999035 0.001 0.001049990375 0 0.0010499904 0.001 0.001049990425 0 0.00104999045 0.001 0.001049990475 0 0.0010499905 0.001
+ 0.001049990525 0 0.00104999055 0.001 0.001049990575 0 0.0010499906 0.001 0.001049990625 0 0.00104999065 0.001 0.001049990675 0 0.0010499907 0.001
+ 0.001049990725 0 0.00104999075 0.001 0.001049990775 0 0.0010499908 0.001 0.001049990825 0 0.00104999085 0.001 0.001049990875 0 0.0010499909 0.001
+ 0.001049990925 0 0.00104999095 0.001 0.001049990975 0 0.001049991 0.001 0.001049991025 0 0.00104999105 0.001 0.001049991075 0 0.0010499911 0.001
+ 0.001049991125 0 0.00104999115 0.001 0.001049991175 0 0.0010499912 0.001 0.001049991225 0 0.00104999125 0.001 0.001049991275 0 0.0010499913 0.001
+ 0.001049991325 0 0.00104999135 0.001 0.001049991375 0 0.0010499914 0.001 0.001049991425 0 0.00104999145 0.001 0.001049991475 0 0.0010499915 0.001
+ 0.001049991525 0 0.00104999155 0.001 0.001049991575 0 0.0010499916 0.001 0.001049991625 0 0.00104999165 0.001 0.001049991675 0 0.0010499917 0.001
+ 0.001049991725 0 0.00104999175 0.001 0.001049991775 0 0.0010499918 0.001 0.001049991825 0 0.00104999185 0.001 0.001049991875 0 0.0010499919 0.001
+ 0.001049991925 0 0.00104999195 0.001 0.001049991975 0 0.001049992 0.001 0.001049992025 0 0.00104999205 0.001 0.001049992075 0 0.0010499921 0.001
+ 0.001049992125 0 0.00104999215 0.001 0.001049992175 0 0.0010499922 0.001 0.001049992225 0 0.00104999225 0.001 0.001049992275 0 0.0010499923 0.001
+ 0.001049992325 0 0.00104999235 0.001 0.001049992375 0 0.0010499924 0.001 0.001049992425 0 0.00104999245 0.001 0.001049992475 0 0.0010499925 0.001
+ 0.001049992525 0 0.00104999255 0.001 0.001049992575 0 0.0010499926 0.001 0.001049992625 0 0.00104999265 0.001 0.001049992675 0 0.0010499927 0.001
+ 0.001049992725 0 0.00104999275 0.001 0.001049992775 0 0.0010499928 0.001 0.001049992825 0 0.00104999285 0.001 0.001049992875 0 0.0010499929 0.001
+ 0.001049992925 0 0.00104999295 0.001 0.001049992975 0 0.001049993 0.001 0.001049999 0 0.001049999025 0.001 0.00104999905 0 0.001049999075 0.001
+ 0.0010499991 0 0.001049999125 0.001 0.00104999915 0 0.001049999175 0.001 0.0010499992 0 0.001049999225 0.001 0.00104999925 0 0.001049999275 0.001
+ 0.0010499993 0 0.001049999325 0.001 0.00104999935 0 0.001049999375 0.001 0.0010499994 0 0.001049999425 0.001 0.00104999945 0 0.001049999475 0.001
+ 0.0010499995 0 0.001049999525 0.001 0.00104999955 0 0.001049999575 0.001 0.0010499996 0 0.001049999625 0.001 0.00104999965 0 0.001049999675 0.001
+ 0.0010499997 0 0.001049999725 0.001 0.00104999975 0 0.001049999775 0.001 0.0010499998 0 0.001049999825 0.001 0.00104999985 0 0.001049999875 0.001
+ 0.0010499999 0 0.001049999925 0.001 0.00104999995 0 0.001049999975 0.001 0.00105 0 0.001050000025 0.001 0.00105000005 0 0.001050000075 0.001
+ 0.0010500001 0 0.001050000125 0.001 0.00105000015 0 0.001050000175 0.001 0.0010500002 0 0.001050000225 0.001 0.00105000025 0 0.001050000275 0.001
+ 0.0010500003 0 0.001050000325 0.001 0.00105000035 0 0.001050000375 0.001 0.0010500004 0 0.001050000425 0.001 0.00105000045 0 0.001050000475 0.001
+ 0.0010500005 0 0.001050000525 0.001 0.00105000055 0 0.001050000575 0.001 0.0010500006 0 0.001050000625 0.001 0.00105000065 0 0.001050000675 0.001
+ 0.0010500007 0 0.001050000725 0.001 0.00105000075 0 0.001050000775 0.001 0.0010500008 0 0.001050000825 0.001 0.00105000085 0 0.001050000875 0.001
+ 0.0010500009 0 0.001050000925 0.001 0.00105000095 0 0.001050000975 0.001 0.001050001 0 0.001050001025 0.001 0.00105000105 0 0.001050001075 0.001
+ 0.0010500011 0 0.001050001125 0.001 0.00105000115 0 0.001050001175 0.001 0.0010500012 0 0.001050001225 0.001 0.00105000125 0 0.001050001275 0.001
+ 0.0010500013 0 0.001050001325 0.001 0.00105000135 0 0.001050001375 0.001 0.0010500014 0 0.001050001425 0.001 0.00105000145 0 0.001050001475 0.001
+ 0.0010500015 0 0.001050001525 0.001 0.00105000155 0 0.001050001575 0.001 0.0010500016 0 0.001050001625 0.001 0.00105000165 0 0.001050001675 0.001
+ 0.0010500017 0 0.001050001725 0.001 0.00105000175 0 0.001050001775 0.001 0.0010500018 0 0.001050001825 0.001 0.00105000185 0 0.001050001875 0.001
+ 0.0010500019 0 0.001050001925 0.001 0.00105000195 0 0.001050001975 0.001 0.001050002 0 0.001050002025 0.001 0.00105000205 0 0.001050002075 0.001
+ 0.0010500021 0 0.001050002125 0.001 0.00105000215 0 0.001050002175 0.001 0.0010500022 0 0.001050002225 0.001 0.00105000225 0 0.001050002275 0.001
+ 0.0010500023 0 0.001050002325 0.001 0.00105000235 0 0.001050002375 0.001 0.0010500024 0 0.001050002425 0.001 0.00105000245 0 0.001050002475 0.001
+ 0.0010500025 0 0.001050002525 0.001 0.00105000255 0 0.001050002575 0.001 0.0010500026 0 0.001050002625 0.001 0.00105000265 0 0.001050002675 0.001
+ 0.0010500027 0 0.001050002725 0.001 0.00105000275 0 0.001050002775 0.001 0.0010500028 0 0.001050002825 0.001 0.00105000285 0 0.001050002875 0.001
+ 0.0010500029 0 0.001050002925 0.001 0.00105000295 0 0.001050002975 0.001 0.001050003 0 0.001099999 0.001 0.001099999025 0 0.00109999905 0.001
+ 0.001099999075 0 0.0010999991 0.001 0.001099999125 0 0.00109999915 0.001 0.001099999175 0 0.0010999992 0.001 0.001099999225 0 0.00109999925 0.001
+ 0.001099999275 0 0.0010999993 0.001 0.001099999325 0 0.00109999935 0.001 0.001099999375 0 0.0010999994 0.001 0.001099999425 0 0.00109999945 0.001
+ 0.001099999475 0 0.0010999995 0.001 0.001099999525 0 0.00109999955 0.001 0.001099999575 0 0.0010999996 0.001 0.001099999625 0 0.00109999965 0.001
+ 0.001099999675 0 0.0010999997 0.001 0.001099999725 0 0.00109999975 0.001 0.001099999775 0 0.0010999998 0.001 0.001099999825 0 0.00109999985 0.001
+ 0.001099999875 0 0.0010999999 0.001 0.001099999925 0 0.00109999995 0.001 0.001099999975 0 0.0011 0.001 0.001100000025 0 0.00110000005 0.001
+ 0.001100000075 0 0.0011000001 0.001 0.001100000125 0 0.00110000015 0.001 0.001100000175 0 0.0011000002 0.001 0.001100000225 0 0.00110000025 0.001
+ 0.001100000275 0 0.0011000003 0.001 0.001100000325 0 0.00110000035 0.001 0.001100000375 0 0.0011000004 0.001 0.001100000425 0 0.00110000045 0.001
+ 0.001100000475 0 0.0011000005 0.001 0.001100000525 0 0.00110000055 0.001 0.001100000575 0 0.0011000006 0.001 0.001100000625 0 0.00110000065 0.001
+ 0.001100000675 0 0.0011000007 0.001 0.001100000725 0 0.00110000075 0.001 0.001100000775 0 0.0011000008 0.001 0.001100000825 0 0.00110000085 0.001
+ 0.001100000875 0 0.0011000009 0.001 0.001100000925 0 0.00110000095 0.001 0.001100000975 0 0.001100001 0.001 0.001100001025 0 0.00110000105 0.001
+ 0.001100001075 0 0.0011000011 0.001 0.001100001125 0 0.00110000115 0.001 0.001100001175 0 0.0011000012 0.001 0.001100001225 0 0.00110000125 0.001
+ 0.001100001275 0 0.0011000013 0.001 0.001100001325 0 0.00110000135 0.001 0.001100001375 0 0.0011000014 0.001 0.001100001425 0 0.00110000145 0.001
+ 0.001100001475 0 0.0011000015 0.001 0.001100001525 0 0.00110000155 0.001 0.001100001575 0 0.0011000016 0.001 0.001100001625 0 0.00110000165 0.001
+ 0.001100001675 0 0.0011000017 0.001 0.001100001725 0 0.00110000175 0.001 0.001100001775 0 0.0011000018 0.001 0.001100001825 0 0.00110000185 0.001
+ 0.001100001875 0 0.0011000019 0.001 0.001100001925 0 0.00110000195 0.001 0.001100001975 0 0.001100002 0.001 0.001100002025 0 0.00110000205 0.001
+ 0.001100002075 0 0.0011000021 0.001 0.001100002125 0 0.00110000215 0.001 0.001100002175 0 0.0011000022 0.001 0.001100002225 0 0.00110000225 0.001
+ 0.001100002275 0 0.0011000023 0.001 0.001100002325 0 0.00110000235 0.001 0.001100002375 0 0.0011000024 0.001 0.001100002425 0 0.00110000245 0.001
+ 0.001100002475 0 0.0011000025 0.001 0.001100002525 0 0.00110000255 0.001 0.001100002575 0 0.0011000026 0.001 0.001100002625 0 0.00110000265 0.001
+ 0.001100002675 0 0.0011000027 0.001 0.001100002725 0 0.00110000275 0.001 0.001100002775 0 0.0011000028 0.001 0.001100002825 0 0.00110000285 0.001
+ 0.001100002875 0 0.0011000029 0.001 0.001100002925 0 0.00110000295 0.001 0.001100002975 0 0.001100003 0.001 0.001149999 0 0.001149999025 0.001
+ 0.00114999905 0 0.001149999075 0.001 0.0011499991 0 0.001149999125 0.001 0.00114999915 0 0.001149999175 0.001 0.0011499992 0 0.001149999225 0.001
+ 0.00114999925 0 0.001149999275 0.001 0.0011499993 0 0.001149999325 0.001 0.00114999935 0 0.001149999375 0.001 0.0011499994 0 0.001149999425 0.001
+ 0.00114999945 0 0.001149999475 0.001 0.0011499995 0 0.001149999525 0.001 0.00114999955 0 0.001149999575 0.001 0.0011499996 0 0.001149999625 0.001
+ 0.00114999965 0 0.001149999675 0.001 0.0011499997 0 0.001149999725 0.001 0.00114999975 0 0.001149999775 0.001 0.0011499998 0 0.001149999825 0.001
+ 0.00114999985 0 0.001149999875 0.001 0.0011499999 0 0.001149999925 0.001 0.00114999995 0 0.001149999975 0.001 0.00115 0 0.001150000025 0.001
+ 0.00115000005 0 0.001150000075 0.001 0.0011500001 0 0.001150000125 0.001 0.00115000015 0 0.001150000175 0.001 0.0011500002 0 0.001150000225 0.001
+ 0.00115000025 0 0.001150000275 0.001 0.0011500003 0 0.001150000325 0.001 0.00115000035 0 0.001150000375 0.001 0.0011500004 0 0.001150000425 0.001
+ 0.00115000045 0 0.001150000475 0.001 0.0011500005 0 0.001150000525 0.001 0.00115000055 0 0.001150000575 0.001 0.0011500006 0 0.001150000625 0.001
+ 0.00115000065 0 0.001150000675 0.001 0.0011500007 0 0.001150000725 0.001 0.00115000075 0 0.001150000775 0.001 0.0011500008 0 0.001150000825 0.001
+ 0.00115000085 0 0.001150000875 0.001 0.0011500009 0 0.001150000925 0.001 0.00115000095 0 0.001150000975 0.001 0.001150001 0 0.001150001025 0.001
+ 0.00115000105 0 0.001150001075 0.001 0.0011500011 0 0.001150001125 0.001 0.00115000115 0 0.001150001175 0.001 0.0011500012 0 0.001150001225 0.001
+ 0.00115000125 0 0.001150001275 0.001 0.0011500013 0 0.001150001325 0.001 0.00115000135 0 0.001150001375 0.001 0.0011500014 0 0.001150001425 0.001
+ 0.00115000145 0 0.001150001475 0.001 0.0011500015 0 0.001150001525 0.001 0.00115000155 0 0.001150001575 0.001 0.0011500016 0 0.001150001625 0.001
+ 0.00115000165 0 0.001150001675 0.001 0.0011500017 0 0.001150001725 0.001 0.00115000175 0 0.001150001775 0.001 0.0011500018 0 0.001150001825 0.001
+ 0.00115000185 0 0.001150001875 0.001 0.0011500019 0 0.001150001925 0.001 0.00115000195 0 0.001150001975 0.001 0.001150002 0 0.001150002025 0.001
+ 0.00115000205 0 0.001150002075 0.001 0.0011500021 0 0.001150002125 0.001 0.00115000215 0 0.001150002175 0.001 0.0011500022 0 0.001150002225 0.001
+ 0.00115000225 0 0.001150002275 0.001 0.0011500023 0 0.001150002325 0.001 0.00115000235 0 0.001150002375 0.001 0.0011500024 0 0.001150002425 0.001
+ 0.00115000245 0 0.001150002475 0.001 0.0011500025 0 0.001150002525 0.001 0.00115000255 0 0.001150002575 0.001 0.0011500026 0 0.001150002625 0.001
+ 0.00115000265 0 0.001150002675 0.001 0.0011500027 0 0.001150002725 0.001 0.00115000275 0 0.001150002775 0.001 0.0011500028 0 0.001150002825 0.001
+ 0.00115000285 0 0.001150002875 0.001 0.0011500029 0 0.001150002925 0.001 0.00115000295 0 0.001150002975 0.001 0.001150003 0 0.001199999 0.001
+ 0.001199999025 0 0.00119999905 0.001 0.001199999075 0 0.0011999991 0.001 0.001199999125 0 0.00119999915 0.001 0.001199999175 0 0.0011999992 0.001
+ 0.001199999225 0 0.00119999925 0.001 0.001199999275 0 0.0011999993 0.001 0.001199999325 0 0.00119999935 0.001 0.001199999375 0 0.0011999994 0.001
+ 0.001199999425 0 0.00119999945 0.001 0.001199999475 0 0.0011999995 0.001 0.001199999525 0 0.00119999955 0.001 0.001199999575 0 0.0011999996 0.001
+ 0.001199999625 0 0.00119999965 0.001 0.001199999675 0 0.0011999997 0.001 0.001199999725 0 0.00119999975 0.001 0.001199999775 0 0.0011999998 0.001
+ 0.001199999825 0 0.00119999985 0.001 0.001199999875 0 0.0011999999 0.001 0.001199999925 0 0.00119999995 0.001 0.001199999975 0 0.0012 0.001
+ 0.001200000025 0 0.00120000005 0.001 0.001200000075 0 0.0012000001 0.001 0.001200000125 0 0.00120000015 0.001 0.001200000175 0 0.0012000002 0.001
+ 0.001200000225 0 0.00120000025 0.001 0.001200000275 0 0.0012000003 0.001 0.001200000325 0 0.00120000035 0.001 0.001200000375 0 0.0012000004 0.001
+ 0.001200000425 0 0.00120000045 0.001 0.001200000475 0 0.0012000005 0.001 0.001200000525 0 0.00120000055 0.001 0.001200000575 0 0.0012000006 0.001
+ 0.001200000625 0 0.00120000065 0.001 0.001200000675 0 0.0012000007 0.001 0.001200000725 0 0.00120000075 0.001 0.001200000775 0 0.0012000008 0.001
+ 0.001200000825 0 0.00120000085 0.001 0.001200000875 0 0.0012000009 0.001 0.001200000925 0 0.00120000095 0.001 0.001200000975 0 0.001200001 0.001
+ 0.001200001025 0 0.00120000105 0.001 0.001200001075 0 0.0012000011 0.001 0.001200001125 0 0.00120000115 0.001 0.001200001175 0 0.0012000012 0.001
+ 0.001200001225 0 0.00120000125 0.001 0.001200001275 0 0.0012000013 0.001 0.001200001325 0 0.00120000135 0.001 0.001200001375 0 0.0012000014 0.001
+ 0.001200001425 0 0.00120000145 0.001 0.001200001475 0 0.0012000015 0.001 0.001200001525 0 0.00120000155 0.001 0.001200001575 0 0.0012000016 0.001
+ 0.001200001625 0 0.00120000165 0.001 0.001200001675 0 0.0012000017 0.001 0.001200001725 0 0.00120000175 0.001 0.001200001775 0 0.0012000018 0.001
+ 0.001200001825 0 0.00120000185 0.001 0.001200001875 0 0.0012000019 0.001 0.001200001925 0 0.00120000195 0.001 0.001200001975 0 0.001200002 0.001
+ 0.001200002025 0 0.00120000205 0.001 0.001200002075 0 0.0012000021 0.001 0.001200002125 0 0.00120000215 0.001 0.001200002175 0 0.0012000022 0.001
+ 0.001200002225 0 0.00120000225 0.001 0.001200002275 0 0.0012000023 0.001 0.001200002325 0 0.00120000235 0.001 0.001200002375 0 0.0012000024 0.001
+ 0.001200002425 0 0.00120000245 0.001 0.001200002475 0 0.0012000025 0.001 0.001200002525 0 0.00120000255 0.001 0.001200002575 0 0.0012000026 0.001
+ 0.001200002625 0 0.00120000265 0.001 0.001200002675 0 0.0012000027 0.001 0.001200002725 0 0.00120000275 0.001 0.001200002775 0 0.0012000028 0.001
+ 0.001200002825 0 0.00120000285 0.001 0.001200002875 0 0.0012000029 0.001 0.001200002925 0 0.00120000295 0.001 0.001200002975 0 0.001200003 0.001
+ 0.001249999 0 0.001249999025 0.001 0.00124999905 0 0.001249999075 0.001 0.0012499991 0 0.001249999125 0.001 0.00124999915 0 0.001249999175 0.001
+ 0.0012499992 0 0.001249999225 0.001 0.00124999925 0 0.001249999275 0.001 0.0012499993 0 0.001249999325 0.001 0.00124999935 0 0.001249999375 0.001
+ 0.0012499994 0 0.001249999425 0.001 0.00124999945 0 0.001249999475 0.001 0.0012499995 0 0.001249999525 0.001 0.00124999955 0 0.001249999575 0.001
+ 0.0012499996 0 0.001249999625 0.001 0.00124999965 0 0.001249999675 0.001 0.0012499997 0 0.001249999725 0.001 0.00124999975 0 0.001249999775 0.001
+ 0.0012499998 0 0.001249999825 0.001 0.00124999985 0 0.001249999875 0.001 0.0012499999 0 0.001249999925 0.001 0.00124999995 0 0.001249999975 0.001
+ 0.00125 0 0.001250000025 0.001 0.00125000005 0 0.001250000075 0.001 0.0012500001 0 0.001250000125 0.001 0.00125000015 0 0.001250000175 0.001
+ 0.0012500002 0 0.001250000225 0.001 0.00125000025 0 0.001250000275 0.001 0.0012500003 0 0.001250000325 0.001 0.00125000035 0 0.001250000375 0.001
+ 0.0012500004 0 0.001250000425 0.001 0.00125000045 0 0.001250000475 0.001 0.0012500005 0 0.001250000525 0.001 0.00125000055 0 0.001250000575 0.001
+ 0.0012500006 0 0.001250000625 0.001 0.00125000065 0 0.001250000675 0.001 0.0012500007 0 0.001250000725 0.001 0.00125000075 0 0.001250000775 0.001
+ 0.0012500008 0 0.001250000825 0.001 0.00125000085 0 0.001250000875 0.001 0.0012500009 0 0.001250000925 0.001 0.00125000095 0 0.001250000975 0.001
+ 0.001250001 0 0.001250001025 0.001 0.00125000105 0 0.001250001075 0.001 0.0012500011 0 0.001250001125 0.001 0.00125000115 0 0.001250001175 0.001
+ 0.0012500012 0 0.001250001225 0.001 0.00125000125 0 0.001250001275 0.001 0.0012500013 0 0.001250001325 0.001 0.00125000135 0 0.001250001375 0.001
+ 0.0012500014 0 0.001250001425 0.001 0.00125000145 0 0.001250001475 0.001 0.0012500015 0 0.001250001525 0.001 0.00125000155 0 0.001250001575 0.001
+ 0.0012500016 0 0.001250001625 0.001 0.00125000165 0 0.001250001675 0.001 0.0012500017 0 0.001250001725 0.001 0.00125000175 0 0.001250001775 0.001
+ 0.0012500018 0 0.001250001825 0.001 0.00125000185 0 0.001250001875 0.001 0.0012500019 0 0.001250001925 0.001 0.00125000195 0 0.001250001975 0.001
+ 0.001250002 0 0.001250002025 0.001 0.00125000205 0 0.001250002075 0.001 0.0012500021 0 0.001250002125 0.001 0.00125000215 0 0.001250002175 0.001
+ 0.0012500022 0 0.001250002225 0.001 0.00125000225 0 0.001250002275 0.001 0.0012500023 0 0.001250002325 0.001 0.00125000235 0 0.001250002375 0.001
+ 0.0012500024 0 0.001250002425 0.001 0.00125000245 0 0.001250002475 0.001 0.0012500025 0 0.001250002525 0.001 0.00125000255 0 0.001250002575 0.001
+ 0.0012500026 0 0.001250002625 0.001 0.00125000265 0 0.001250002675 0.001 0.0012500027 0 0.001250002725 0.001 0.00125000275 0 0.001250002775 0.001
+ 0.0012500028 0 0.001250002825 0.001 0.00125000285 0 0.001250002875 0.001 0.0012500029 0 0.001250002925 0.001 0.00125000295 0 0.001250002975 0.001
+ 0.001250003 0 0.001289999 0.001 0.001289999025 0 0.00128999905 0.001 0.001289999075 0 0.0012899991 0.001 0.001289999125 0 0.00128999915 0.001
+ 0.001289999175 0 0.0012899992 0.001 0.001289999225 0 0.00128999925 0.001 0.001289999275 0 0.0012899993 0.001 0.001289999325 0 0.00128999935 0.001
+ 0.001289999375 0 0.0012899994 0.001 0.001289999425 0 0.00128999945 0.001 0.001289999475 0 0.0012899995 0.001 0.001289999525 0 0.00128999955 0.001
+ 0.001289999575 0 0.0012899996 0.001 0.001289999625 0 0.00128999965 0.001 0.001289999675 0 0.0012899997 0.001 0.001289999725 0 0.00128999975 0.001
+ 0.001289999775 0 0.0012899998 0.001 0.001289999825 0 0.00128999985 0.001 0.001289999875 0 0.0012899999 0.001 0.001289999925 0 0.00128999995 0.001
+ 0.001289999975 0 0.00129 0.001 0.001290000025 0 0.00129000005 0.001 0.001290000075 0 0.0012900001 0.001 0.001290000125 0 0.00129000015 0.001
+ 0.001290000175 0 0.0012900002 0.001 0.001290000225 0 0.00129000025 0.001 0.001290000275 0 0.0012900003 0.001 0.001290000325 0 0.00129000035 0.001
+ 0.001290000375 0 0.0012900004 0.001 0.001290000425 0 0.00129000045 0.001 0.001290000475 0 0.0012900005 0.001 0.001290000525 0 0.00129000055 0.001
+ 0.001290000575 0 0.0012900006 0.001 0.001290000625 0 0.00129000065 0.001 0.001290000675 0 0.0012900007 0.001 0.001290000725 0 0.00129000075 0.001
+ 0.001290000775 0 0.0012900008 0.001 0.001290000825 0 0.00129000085 0.001 0.001290000875 0 0.0012900009 0.001 0.001290000925 0 0.00129000095 0.001
+ 0.001290000975 0 0.001290001 0.001 0.001290001025 0 0.00129000105 0.001 0.001290001075 0 0.0012900011 0.001 0.001290001125 0 0.00129000115 0.001
+ 0.001290001175 0 0.0012900012 0.001 0.001290001225 0 0.00129000125 0.001 0.001290001275 0 0.0012900013 0.001 0.001290001325 0 0.00129000135 0.001
+ 0.001290001375 0 0.0012900014 0.001 0.001290001425 0 0.00129000145 0.001 0.001290001475 0 0.0012900015 0.001 0.001290001525 0 0.00129000155 0.001
+ 0.001290001575 0 0.0012900016 0.001 0.001290001625 0 0.00129000165 0.001 0.001290001675 0 0.0012900017 0.001 0.001290001725 0 0.00129000175 0.001
+ 0.001290001775 0 0.0012900018 0.001 0.001290001825 0 0.00129000185 0.001 0.001290001875 0 0.0012900019 0.001 0.001290001925 0 0.00129000195 0.001
+ 0.001290001975 0 0.001290002 0.001 0.001290002025 0 0.00129000205 0.001 0.001290002075 0 0.0012900021 0.001 0.001290002125 0 0.00129000215 0.001
+ 0.001290002175 0 0.0012900022 0.001 0.001290002225 0 0.00129000225 0.001 0.001290002275 0 0.0012900023 0.001 0.001290002325 0 0.00129000235 0.001
+ 0.001290002375 0 0.0012900024 0.001 0.001290002425 0 0.00129000245 0.001 0.001290002475 0 0.0012900025 0.001 0.001290002525 0 0.00129000255 0.001
+ 0.001290002575 0 0.0012900026 0.001 0.001290002625 0 0.00129000265 0.001 0.001290002675 0 0.0012900027 0.001 0.001290002725 0 0.00129000275 0.001
+ 0.001290002775 0 0.0012900028 0.001 0.001290002825 0 0.00129000285 0.001 0.001290002875 0 0.0012900029 0.001 0.001290002925 0 0.00129000295 0.001
+ 0.001290002975 0 0.001290003 0.001 0.001299999 0 0.001299999025 0.001 0.00129999905 0 0.001299999075 0.001 0.0012999991 0 0.001299999125 0.001
+ 0.00129999915 0 0.001299999175 0.001 0.0012999992 0 0.001299999225 0.001 0.00129999925 0 0.001299999275 0.001 0.0012999993 0 0.001299999325 0.001
+ 0.00129999935 0 0.001299999375 0.001 0.0012999994 0 0.001299999425 0.001 0.00129999945 0 0.001299999475 0.001 0.0012999995 0 0.001299999525 0.001
+ 0.00129999955 0 0.001299999575 0.001 0.0012999996 0 0.001299999625 0.001 0.00129999965 0 0.001299999675 0.001 0.0012999997 0 0.001299999725 0.001
+ 0.00129999975 0 0.001299999775 0.001 0.0012999998 0 0.001299999825 0.001 0.00129999985 0 0.001299999875 0.001 0.0012999999 0 0.001299999925 0.001
+ 0.00129999995 0 0.001299999975 0.001 0.0013 0 0.001300000025 0.001 0.00130000005 0 0.001300000075 0.001 0.0013000001 0 0.001300000125 0.001
+ 0.00130000015 0 0.001300000175 0.001 0.0013000002 0 0.001300000225 0.001 0.00130000025 0 0.001300000275 0.001 0.0013000003 0 0.001300000325 0.001
+ 0.00130000035 0 0.001300000375 0.001 0.0013000004 0 0.001300000425 0.001 0.00130000045 0 0.001300000475 0.001 0.0013000005 0 0.001300000525 0.001
+ 0.00130000055 0 0.001300000575 0.001 0.0013000006 0 0.001300000625 0.001 0.00130000065 0 0.001300000675 0.001 0.0013000007 0 0.001300000725 0.001
+ 0.00130000075 0 0.001300000775 0.001 0.0013000008 0 0.001300000825 0.001 0.00130000085 0 0.001300000875 0.001 0.0013000009 0 0.001300000925 0.001
+ 0.00130000095 0 0.001300000975 0.001 0.001300001 0 0.001300001025 0.001 0.00130000105 0 0.001300001075 0.001 0.0013000011 0 0.001300001125 0.001
+ 0.00130000115 0 0.001300001175 0.001 0.0013000012 0 0.001300001225 0.001 0.00130000125 0 0.001300001275 0.001 0.0013000013 0 0.001300001325 0.001
+ 0.00130000135 0 0.001300001375 0.001 0.0013000014 0 0.001300001425 0.001 0.00130000145 0 0.001300001475 0.001 0.0013000015 0 0.001300001525 0.001
+ 0.00130000155 0 0.001300001575 0.001 0.0013000016 0 0.001300001625 0.001 0.00130000165 0 0.001300001675 0.001 0.0013000017 0 0.001300001725 0.001
+ 0.00130000175 0 0.001300001775 0.001 0.0013000018 0 0.001300001825 0.001 0.00130000185 0 0.001300001875 0.001 0.0013000019 0 0.001300001925 0.001
+ 0.00130000195 0 0.001300001975 0.001 0.001300002 0 0.001300002025 0.001 0.00130000205 0 0.001300002075 0.001 0.0013000021 0 0.001300002125 0.001
+ 0.00130000215 0 0.001300002175 0.001 0.0013000022 0 0.001300002225 0.001 0.00130000225 0 0.001300002275 0.001 0.0013000023 0 0.001300002325 0.001
+ 0.00130000235 0 0.001300002375 0.001 0.0013000024 0 0.001300002425 0.001 0.00130000245 0 0.001300002475 0.001 0.0013000025 0 0.001300002525 0.001
+ 0.00130000255 0 0.001300002575 0.001 0.0013000026 0 0.001300002625 0.001 0.00130000265 0 0.001300002675 0.001 0.0013000027 0 0.001300002725 0.001
+ 0.00130000275 0 0.001300002775 0.001 0.0013000028 0 0.001300002825 0.001 0.00130000285 0 0.001300002875 0.001 0.0013000029 0 0.001300002925 0.001
+ 0.00130000295 0 0.001300002975 0.001 0.001300003 0 0.001349998 0.001 0.001349998025 0 0.00134999805 0.001 0.001349998075 0 0.0013499981 0.001
+ 0.001349998125 0 0.00134999815 0.001 0.001349998175 0 0.0013499982 0.001 0.001349998225 0 0.00134999825 0.001 0.001349998275 0 0.0013499983 0.001
+ 0.001349998325 0 0.00134999835 0.001 0.001349998375 0 0.0013499984 0.001 0.001349998425 0 0.00134999845 0.001 0.001349998475 0 0.0013499985 0.001
+ 0.001349998525 0 0.00134999855 0.001 0.001349998575 0 0.0013499986 0.001 0.001349998625 0 0.00134999865 0.001 0.001349998675 0 0.0013499987 0.001
+ 0.001349998725 0 0.00134999875 0.001 0.001349998775 0 0.0013499988 0.001 0.001349998825 0 0.00134999885 0.001 0.001349998875 0 0.0013499989 0.001
+ 0.001349998925 0 0.00134999895 0.001 0.001349998975 0 0.001349999 0.001 0.001349999025 0 0.00134999905 0.001 0.001349999075 0 0.0013499991 0.001
+ 0.001349999125 0 0.00134999915 0.001 0.001349999175 0 0.0013499992 0.001 0.001349999225 0 0.00134999925 0.001 0.001349999275 0 0.0013499993 0.001
+ 0.001349999325 0 0.00134999935 0.001 0.001349999375 0 0.0013499994 0.001 0.001349999425 0 0.00134999945 0.001 0.001349999475 0 0.0013499995 0.001
+ 0.001349999525 0 0.00134999955 0.001 0.001349999575 0 0.0013499996 0.001 0.001349999625 0 0.00134999965 0.001 0.001349999675 0 0.0013499997 0.001
+ 0.001349999725 0 0.00134999975 0.001 0.001349999775 0 0.0013499998 0.001 0.001349999825 0 0.00134999985 0.001 0.001349999875 0 0.0013499999 0.001
+ 0.001349999925 0 0.00134999995 0.001 0.001349999975 0 0.00135 0.001 0.001350000025 0 0.00135000005 0.001 0.001350000075 0 0.0013500001 0.001
+ 0.001350000125 0 0.00135000015 0.001 0.001350000175 0 0.0013500002 0.001 0.001350000225 0 0.00135000025 0.001 0.001350000275 0 0.0013500003 0.001
+ 0.001350000325 0 0.00135000035 0.001 0.001350000375 0 0.0013500004 0.001 0.001350000425 0 0.00135000045 0.001 0.001350000475 0 0.0013500005 0.001
+ 0.001350000525 0 0.00135000055 0.001 0.001350000575 0 0.0013500006 0.001 0.001350000625 0 0.00135000065 0.001 0.001350000675 0 0.0013500007 0.001
+ 0.001350000725 0 0.00135000075 0.001 0.001350000775 0 0.0013500008 0.001 0.001350000825 0 0.00135000085 0.001 0.001350000875 0 0.0013500009 0.001
+ 0.001350000925 0 0.00135000095 0.001 0.001350000975 0 0.001350001 0.001 0.001350001025 0 0.00135000105 0.001 0.001350001075 0 0.0013500011 0.001
+ 0.001350001125 0 0.00135000115 0.001 0.001350001175 0 0.0013500012 0.001 0.001350001225 0 0.00135000125 0.001 0.001350001275 0 0.0013500013 0.001
+ 0.001350001325 0 0.00135000135 0.001 0.001350001375 0 0.0013500014 0.001 0.001350001425 0 0.00135000145 0.001 0.001350001475 0 0.0013500015 0.001
+ 0.001350001525 0 0.00135000155 0.001 0.001350001575 0 0.0013500016 0.001 0.001350001625 0 0.00135000165 0.001 0.001350001675 0 0.0013500017 0.001
+ 0.001350001725 0 0.00135000175 0.001 0.001350001775 0 0.0013500018 0.001 0.001350001825 0 0.00135000185 0.001 0.001350001875 0 0.0013500019 0.001
+ 0.001350001925 0 0.00135000195 0.001 0.001350001975 0 0.001350002 0.001 0.001349999 0 0.001349999025 0.001 0.00134999905 0 0.001349999075 0.001
+ 0.0013499991 0 0.001349999125 0.001 0.00134999915 0 0.001349999175 0.001 0.0013499992 0 0.001349999225 0.001 0.00134999925 0 0.001349999275 0.001
+ 0.0013499993 0 0.001349999325 0.001 0.00134999935 0 0.001349999375 0.001 0.0013499994 0 0.001349999425 0.001 0.00134999945 0 0.001349999475 0.001
+ 0.0013499995 0 0.001349999525 0.001 0.00134999955 0 0.001349999575 0.001 0.0013499996 0 0.001349999625 0.001 0.00134999965 0 0.001349999675 0.001
+ 0.0013499997 0 0.001349999725 0.001 0.00134999975 0 0.001349999775 0.001 0.0013499998 0 0.001349999825 0.001 0.00134999985 0 0.001349999875 0.001
+ 0.0013499999 0 0.001349999925 0.001 0.00134999995 0 0.001349999975 0.001 0.00135 0 0.001350000025 0.001 0.00135000005 0 0.001350000075 0.001
+ 0.0013500001 0 0.001350000125 0.001 0.00135000015 0 0.001350000175 0.001 0.0013500002 0 0.001350000225 0.001 0.00135000025 0 0.001350000275 0.001
+ 0.0013500003 0 0.001350000325 0.001 0.00135000035 0 0.001350000375 0.001 0.0013500004 0 0.001350000425 0.001 0.00135000045 0 0.001350000475 0.001
+ 0.0013500005 0 0.001350000525 0.001 0.00135000055 0 0.001350000575 0.001 0.0013500006 0 0.001350000625 0.001 0.00135000065 0 0.001350000675 0.001
+ 0.0013500007 0 0.001350000725 0.001 0.00135000075 0 0.001350000775 0.001 0.0013500008 0 0.001350000825 0.001 0.00135000085 0 0.001350000875 0.001
+ 0.0013500009 0 0.001350000925 0.001 0.00135000095 0 0.001350000975 0.001 0.001350001 0 0.001350001025 0.001 0.00135000105 0 0.001350001075 0.001
+ 0.0013500011 0 0.001350001125 0.001 0.00135000115 0 0.001350001175 0.001 0.0013500012 0 0.001350001225 0.001 0.00135000125 0 0.001350001275 0.001
+ 0.0013500013 0 0.001350001325 0.001 0.00135000135 0 0.001350001375 0.001 0.0013500014 0 0.001350001425 0.001 0.00135000145 0 0.001350001475 0.001
+ 0.0013500015 0 0.001350001525 0.001 0.00135000155 0 0.001350001575 0.001 0.0013500016 0 0.001350001625 0.001 0.00135000165 0 0.001350001675 0.001
+ 0.0013500017 0 0.001350001725 0.001 0.00135000175 0 0.001350001775 0.001 0.0013500018 0 0.001350001825 0.001 0.00135000185 0 0.001350001875 0.001
+ 0.0013500019 0 0.001350001925 0.001 0.00135000195 0 0.001350001975 0.001 0.001350002 0 0.001350002025 0.001 0.00135000205 0 0.001350002075 0.001
+ 0.0013500021 0 0.001350002125 0.001 0.00135000215 0 0.001350002175 0.001 0.0013500022 0 0.001350002225 0.001 0.00135000225 0 0.001350002275 0.001
+ 0.0013500023 0 0.001350002325 0.001 0.00135000235 0 0.001350002375 0.001 0.0013500024 0 0.001350002425 0.001 0.00135000245 0 0.001350002475 0.001
+ 0.0013500025 0 0.001350002525 0.001 0.00135000255 0 0.001350002575 0.001 0.0013500026 0 0.001350002625 0.001 0.00135000265 0 0.001350002675 0.001
+ 0.0013500027 0 0.001350002725 0.001 0.00135000275 0 0.001350002775 0.001 0.0013500028 0 0.001350002825 0.001 0.00135000285 0 0.001350002875 0.001
+ 0.0013500029 0 0.001350002925 0.001 0.00135000295 0 0.001350002975 0.001 0.001350003 0 0.001399999 0.001 0.001399999025 0 0.00139999905 0.001
+ 0.001399999075 0 0.0013999991 0.001 0.001399999125 0 0.00139999915 0.001 0.001399999175 0 0.0013999992 0.001 0.001399999225 0 0.00139999925 0.001
+ 0.001399999275 0 0.0013999993 0.001 0.001399999325 0 0.00139999935 0.001 0.001399999375 0 0.0013999994 0.001 0.001399999425 0 0.00139999945 0.001
+ 0.001399999475 0 0.0013999995 0.001 0.001399999525 0 0.00139999955 0.001 0.001399999575 0 0.0013999996 0.001 0.001399999625 0 0.00139999965 0.001
+ 0.001399999675 0 0.0013999997 0.001 0.001399999725 0 0.00139999975 0.001 0.001399999775 0 0.0013999998 0.001 0.001399999825 0 0.00139999985 0.001
+ 0.001399999875 0 0.0013999999 0.001 0.001399999925 0 0.00139999995 0.001 0.001399999975 0 0.0014 0.001 0.001400000025 0 0.00140000005 0.001
+ 0.001400000075 0 0.0014000001 0.001 0.001400000125 0 0.00140000015 0.001 0.001400000175 0 0.0014000002 0.001 0.001400000225 0 0.00140000025 0.001
+ 0.001400000275 0 0.0014000003 0.001 0.001400000325 0 0.00140000035 0.001 0.001400000375 0 0.0014000004 0.001 0.001400000425 0 0.00140000045 0.001
+ 0.001400000475 0 0.0014000005 0.001 0.001400000525 0 0.00140000055 0.001 0.001400000575 0 0.0014000006 0.001 0.001400000625 0 0.00140000065 0.001
+ 0.001400000675 0 0.0014000007 0.001 0.001400000725 0 0.00140000075 0.001 0.001400000775 0 0.0014000008 0.001 0.001400000825 0 0.00140000085 0.001
+ 0.001400000875 0 0.0014000009 0.001 0.001400000925 0 0.00140000095 0.001 0.001400000975 0 0.001400001 0.001 0.001400001025 0 0.00140000105 0.001
+ 0.001400001075 0 0.0014000011 0.001 0.001400001125 0 0.00140000115 0.001 0.001400001175 0 0.0014000012 0.001 0.001400001225 0 0.00140000125 0.001
+ 0.001400001275 0 0.0014000013 0.001 0.001400001325 0 0.00140000135 0.001 0.001400001375 0 0.0014000014 0.001 0.001400001425 0 0.00140000145 0.001
+ 0.001400001475 0 0.0014000015 0.001 0.001400001525 0 0.00140000155 0.001 0.001400001575 0 0.0014000016 0.001 0.001400001625 0 0.00140000165 0.001
+ 0.001400001675 0 0.0014000017 0.001 0.001400001725 0 0.00140000175 0.001 0.001400001775 0 0.0014000018 0.001 0.001400001825 0 0.00140000185 0.001
+ 0.001400001875 0 0.0014000019 0.001 0.001400001925 0 0.00140000195 0.001 0.001400001975 0 0.001400002 0.001 0.001400002025 0 0.00140000205 0.001
+ 0.001400002075 0 0.0014000021 0.001 0.001400002125 0 0.00140000215 0.001 0.001400002175 0 0.0014000022 0.001 0.001400002225 0 0.00140000225 0.001
+ 0.001400002275 0 0.0014000023 0.001 0.001400002325 0 0.00140000235 0.001 0.001400002375 0 0.0014000024 0.001 0.001400002425 0 0.00140000245 0.001
+ 0.001400002475 0 0.0014000025 0.001 0.001400002525 0 0.00140000255 0.001 0.001400002575 0 0.0014000026 0.001 0.001400002625 0 0.00140000265 0.001
+ 0.001400002675 0 0.0014000027 0.001 0.001400002725 0 0.00140000275 0.001 0.001400002775 0 0.0014000028 0.001 0.001400002825 0 0.00140000285 0.001
+ 0.001400002875 0 0.0014000029 0.001 0.001400002925 0 0.00140000295 0.001 0.001400002975 0 0.001400003 0.001 0.001449999 0 0.001449999025 0.001
+ 0.00144999905 0 0.001449999075 0.001 0.0014499991 0 0.001449999125 0.001 0.00144999915 0 0.001449999175 0.001 0.0014499992 0 0.001449999225 0.001
+ 0.00144999925 0 0.001449999275 0.001 0.0014499993 0 0.001449999325 0.001 0.00144999935 0 0.001449999375 0.001 0.0014499994 0 0.001449999425 0.001
+ 0.00144999945 0 0.001449999475 0.001 0.0014499995 0 0.001449999525 0.001 0.00144999955 0 0.001449999575 0.001 0.0014499996 0 0.001449999625 0.001
+ 0.00144999965 0 0.001449999675 0.001 0.0014499997 0 0.001449999725 0.001 0.00144999975 0 0.001449999775 0.001 0.0014499998 0 0.001449999825 0.001
+ 0.00144999985 0 0.001449999875 0.001 0.0014499999 0 0.001449999925 0.001 0.00144999995 0 0.001449999975 0.001 0.00145 0 0.001450000025 0.001
+ 0.00145000005 0 0.001450000075 0.001 0.0014500001 0 0.001450000125 0.001 0.00145000015 0 0.001450000175 0.001 0.0014500002 0 0.001450000225 0.001
+ 0.00145000025 0 0.001450000275 0.001 0.0014500003 0 0.001450000325 0.001 0.00145000035 0 0.001450000375 0.001 0.0014500004 0 0.001450000425 0.001
+ 0.00145000045 0 0.001450000475 0.001 0.0014500005 0 0.001450000525 0.001 0.00145000055 0 0.001450000575 0.001 0.0014500006 0 0.001450000625 0.001
+ 0.00145000065 0 0.001450000675 0.001 0.0014500007 0 0.001450000725 0.001 0.00145000075 0 0.001450000775 0.001 0.0014500008 0 0.001450000825 0.001
+ 0.00145000085 0 0.001450000875 0.001 0.0014500009 0 0.001450000925 0.001 0.00145000095 0 0.001450000975 0.001 0.001450001 0 0.001450001025 0.001
+ 0.00145000105 0 0.001450001075 0.001 0.0014500011 0 0.001450001125 0.001 0.00145000115 0 0.001450001175 0.001 0.0014500012 0 0.001450001225 0.001
+ 0.00145000125 0 0.001450001275 0.001 0.0014500013 0 0.001450001325 0.001 0.00145000135 0 0.001450001375 0.001 0.0014500014 0 0.001450001425 0.001
+ 0.00145000145 0 0.001450001475 0.001 0.0014500015 0 0.001450001525 0.001 0.00145000155 0 0.001450001575 0.001 0.0014500016 0 0.001450001625 0.001
+ 0.00145000165 0 0.001450001675 0.001 0.0014500017 0 0.001450001725 0.001 0.00145000175 0 0.001450001775 0.001 0.0014500018 0 0.001450001825 0.001
+ 0.00145000185 0 0.001450001875 0.001 0.0014500019 0 0.001450001925 0.001 0.00145000195 0 0.001450001975 0.001 0.001450002 0 0.001450002025 0.001
+ 0.00145000205 0 0.001450002075 0.001 0.0014500021 0 0.001450002125 0.001 0.00145000215 0 0.001450002175 0.001 0.0014500022 0 0.001450002225 0.001
+ 0.00145000225 0 0.001450002275 0.001 0.0014500023 0 0.001450002325 0.001 0.00145000235 0 0.001450002375 0.001 0.0014500024 0 0.001450002425 0.001
+ 0.00145000245 0 0.001450002475 0.001 0.0014500025 0 0.001450002525 0.001 0.00145000255 0 0.001450002575 0.001 0.0014500026 0 0.001450002625 0.001
+ 0.00145000265 0 0.001450002675 0.001 0.0014500027 0 0.001450002725 0.001 0.00145000275 0 0.001450002775 0.001 0.0014500028 0 0.001450002825 0.001
+ 0.00145000285 0 0.001450002875 0.001 0.0014500029 0 0.001450002925 0.001 0.00145000295 0 0.001450002975 0.001 0.001450003 0 0.001499999 0.001
+ 0.001499999025 0 0.00149999905 0.001 0.001499999075 0 0.0014999991 0.001 0.001499999125 0 0.00149999915 0.001 0.001499999175 0 0.0014999992 0.001
+ 0.001499999225 0 0.00149999925 0.001 0.001499999275 0 0.0014999993 0.001 0.001499999325 0 0.00149999935 0.001 0.001499999375 0 0.0014999994 0.001
+ 0.001499999425 0 0.00149999945 0.001 0.001499999475 0 0.0014999995 0.001 0.001499999525 0 0.00149999955 0.001 0.001499999575 0 0.0014999996 0.001
+ 0.001499999625 0 0.00149999965 0.001 0.001499999675 0 0.0014999997 0.001 0.001499999725 0 0.00149999975 0.001 0.001499999775 0 0.0014999998 0.001
+ 0.001499999825 0 0.00149999985 0.001 0.001499999875 0 0.0014999999 0.001 0.001499999925 0 0.00149999995 0.001 0.001499999975 0 0.0015 0.001
+ 0.001500000025 0 0.00150000005 0.001 0.001500000075 0 0.0015000001 0.001 0.001500000125 0 0.00150000015 0.001 0.001500000175 0 0.0015000002 0.001
+ 0.001500000225 0 0.00150000025 0.001 0.001500000275 0 0.0015000003 0.001 0.001500000325 0 0.00150000035 0.001 0.001500000375 0 0.0015000004 0.001
+ 0.001500000425 0 0.00150000045 0.001 0.001500000475 0 0.0015000005 0.001 0.001500000525 0 0.00150000055 0.001 0.001500000575 0 0.0015000006 0.001
+ 0.001500000625 0 0.00150000065 0.001 0.001500000675 0 0.0015000007 0.001 0.001500000725 0 0.00150000075 0.001 0.001500000775 0 0.0015000008 0.001
+ 0.001500000825 0 0.00150000085 0.001 0.001500000875 0 0.0015000009 0.001 0.001500000925 0 0.00150000095 0.001 0.001500000975 0 0.001500001 0.001
+ 0.001500001025 0 0.00150000105 0.001 0.001500001075 0 0.0015000011 0.001 0.001500001125 0 0.00150000115 0.001 0.001500001175 0 0.0015000012 0.001
+ 0.001500001225 0 0.00150000125 0.001 0.001500001275 0 0.0015000013 0.001 0.001500001325 0 0.00150000135 0.001 0.001500001375 0 0.0015000014 0.001
+ 0.001500001425 0 0.00150000145 0.001 0.001500001475 0 0.0015000015 0.001 0.001500001525 0 0.00150000155 0.001 0.001500001575 0 0.0015000016 0.001
+ 0.001500001625 0 0.00150000165 0.001 0.001500001675 0 0.0015000017 0.001 0.001500001725 0 0.00150000175 0.001 0.001500001775 0 0.0015000018 0.001
+ 0.001500001825 0 0.00150000185 0.001 0.001500001875 0 0.0015000019 0.001 0.001500001925 0 0.00150000195 0.001 0.001500001975 0 0.001500002 0.001
+ 0.001500002025 0 0.00150000205 0.001 0.001500002075 0 0.0015000021 0.001 0.001500002125 0 0.00150000215 0.001 0.001500002175 0 0.0015000022 0.001
+ 0.001500002225 0 0.00150000225 0.001 0.001500002275 0 0.0015000023 0.001 0.001500002325 0 0.00150000235 0.001 0.001500002375 0 0.0015000024 0.001
+ 0.001500002425 0 0.00150000245 0.001 0.001500002475 0 0.0015000025 0.001 0.001500002525 0 0.00150000255 0.001 0.001500002575 0 0.0015000026 0.001
+ 0.001500002625 0 0.00150000265 0.001 0.001500002675 0 0.0015000027 0.001 0.001500002725 0 0.00150000275 0.001 0.001500002775 0 0.0015000028 0.001
+ 0.001500002825 0 0.00150000285 0.001 0.001500002875 0 0.0015000029 0.001 0.001500002925 0 0.00150000295 0.001 0.001500002975 0 0.001500003 0.001
+ 0.001549999 0 0.001549999025 0.001 0.00154999905 0 0.001549999075 0.001 0.0015499991 0 0.001549999125 0.001 0.00154999915 0 0.001549999175 0.001
+ 0.0015499992 0 0.001549999225 0.001 0.00154999925 0 0.001549999275 0.001 0.0015499993 0 0.001549999325 0.001 0.00154999935 0 0.001549999375 0.001
+ 0.0015499994 0 0.001549999425 0.001 0.00154999945 0 0.001549999475 0.001 0.0015499995 0 0.001549999525 0.001 0.00154999955 0 0.001549999575 0.001
+ 0.0015499996 0 0.001549999625 0.001 0.00154999965 0 0.001549999675 0.001 0.0015499997 0 0.001549999725 0.001 0.00154999975 0 0.001549999775 0.001
+ 0.0015499998 0 0.001549999825 0.001 0.00154999985 0 0.001549999875 0.001 0.0015499999 0 0.001549999925 0.001 0.00154999995 0 0.001549999975 0.001
+ 0.00155 0 0.001550000025 0.001 0.00155000005 0 0.001550000075 0.001 0.0015500001 0 0.001550000125 0.001 0.00155000015 0 0.001550000175 0.001
+ 0.0015500002 0 0.001550000225 0.001 0.00155000025 0 0.001550000275 0.001 0.0015500003 0 0.001550000325 0.001 0.00155000035 0 0.001550000375 0.001
+ 0.0015500004 0 0.001550000425 0.001 0.00155000045 0 0.001550000475 0.001 0.0015500005 0 0.001550000525 0.001 0.00155000055 0 0.001550000575 0.001
+ 0.0015500006 0 0.001550000625 0.001 0.00155000065 0 0.001550000675 0.001 0.0015500007 0 0.001550000725 0.001 0.00155000075 0 0.001550000775 0.001
+ 0.0015500008 0 0.001550000825 0.001 0.00155000085 0 0.001550000875 0.001 0.0015500009 0 0.001550000925 0.001 0.00155000095 0 0.001550000975 0.001
+ 0.001550001 0 0.001550001025 0.001 0.00155000105 0 0.001550001075 0.001 0.0015500011 0 0.001550001125 0.001 0.00155000115 0 0.001550001175 0.001
+ 0.0015500012 0 0.001550001225 0.001 0.00155000125 0 0.001550001275 0.001 0.0015500013 0 0.001550001325 0.001 0.00155000135 0 0.001550001375 0.001
+ 0.0015500014 0 0.001550001425 0.001 0.00155000145 0 0.001550001475 0.001 0.0015500015 0 0.001550001525 0.001 0.00155000155 0 0.001550001575 0.001
+ 0.0015500016 0 0.001550001625 0.001 0.00155000165 0 0.001550001675 0.001 0.0015500017 0 0.001550001725 0.001 0.00155000175 0 0.001550001775 0.001
+ 0.0015500018 0 0.001550001825 0.001 0.00155000185 0 0.001550001875 0.001 0.0015500019 0 0.001550001925 0.001 0.00155000195 0 0.001550001975 0.001
+ 0.001550002 0 0.001550002025 0.001 0.00155000205 0 0.001550002075 0.001 0.0015500021 0 0.001550002125 0.001 0.00155000215 0 0.001550002175 0.001
+ 0.0015500022 0 0.001550002225 0.001 0.00155000225 0 0.001550002275 0.001 0.0015500023 0 0.001550002325 0.001 0.00155000235 0 0.001550002375 0.001
+ 0.0015500024 0 0.001550002425 0.001 0.00155000245 0 0.001550002475 0.001 0.0015500025 0 0.001550002525 0.001 0.00155000255 0 0.001550002575 0.001
+ 0.0015500026 0 0.001550002625 0.001 0.00155000265 0 0.001550002675 0.001 0.0015500027 0 0.001550002725 0.001 0.00155000275 0 0.001550002775 0.001
+ 0.0015500028 0 0.001550002825 0.001 0.00155000285 0 0.001550002875 0.001 0.0015500029 0 0.001550002925 0.001 0.00155000295 0 0.001550002975 0.001
+ 0.001550003 0 0.001589999 0.001 0.001589999025 0 0.00158999905 0.001 0.001589999075 0 0.0015899991 0.001 0.001589999125 0 0.00158999915 0.001
+ 0.001589999175 0 0.0015899992 0.001 0.001589999225 0 0.00158999925 0.001 0.001589999275 0 0.0015899993 0.001 0.001589999325 0 0.00158999935 0.001
+ 0.001589999375 0 0.0015899994 0.001 0.001589999425 0 0.00158999945 0.001 0.001589999475 0 0.0015899995 0.001 0.001589999525 0 0.00158999955 0.001
+ 0.001589999575 0 0.0015899996 0.001 0.001589999625 0 0.00158999965 0.001 0.001589999675 0 0.0015899997 0.001 0.001589999725 0 0.00158999975 0.001
+ 0.001589999775 0 0.0015899998 0.001 0.001589999825 0 0.00158999985 0.001 0.001589999875 0 0.0015899999 0.001 0.001589999925 0 0.00158999995 0.001
+ 0.001589999975 0 0.00159 0.001 0.001590000025 0 0.00159000005 0.001 0.001590000075 0 0.0015900001 0.001 0.001590000125 0 0.00159000015 0.001
+ 0.001590000175 0 0.0015900002 0.001 0.001590000225 0 0.00159000025 0.001 0.001590000275 0 0.0015900003 0.001 0.001590000325 0 0.00159000035 0.001
+ 0.001590000375 0 0.0015900004 0.001 0.001590000425 0 0.00159000045 0.001 0.001590000475 0 0.0015900005 0.001 0.001590000525 0 0.00159000055 0.001
+ 0.001590000575 0 0.0015900006 0.001 0.001590000625 0 0.00159000065 0.001 0.001590000675 0 0.0015900007 0.001 0.001590000725 0 0.00159000075 0.001
+ 0.001590000775 0 0.0015900008 0.001 0.001590000825 0 0.00159000085 0.001 0.001590000875 0 0.0015900009 0.001 0.001590000925 0 0.00159000095 0.001
+ 0.001590000975 0 0.001590001 0.001 0.001590001025 0 0.00159000105 0.001 0.001590001075 0 0.0015900011 0.001 0.001590001125 0 0.00159000115 0.001
+ 0.001590001175 0 0.0015900012 0.001 0.001590001225 0 0.00159000125 0.001 0.001590001275 0 0.0015900013 0.001 0.001590001325 0 0.00159000135 0.001
+ 0.001590001375 0 0.0015900014 0.001 0.001590001425 0 0.00159000145 0.001 0.001590001475 0 0.0015900015 0.001 0.001590001525 0 0.00159000155 0.001
+ 0.001590001575 0 0.0015900016 0.001 0.001590001625 0 0.00159000165 0.001 0.001590001675 0 0.0015900017 0.001 0.001590001725 0 0.00159000175 0.001
+ 0.001590001775 0 0.0015900018 0.001 0.001590001825 0 0.00159000185 0.001 0.001590001875 0 0.0015900019 0.001 0.001590001925 0 0.00159000195 0.001
+ 0.001590001975 0 0.001590002 0.001 0.001590002025 0 0.00159000205 0.001 0.001590002075 0 0.0015900021 0.001 0.001590002125 0 0.00159000215 0.001
+ 0.001590002175 0 0.0015900022 0.001 0.001590002225 0 0.00159000225 0.001 0.001590002275 0 0.0015900023 0.001 0.001590002325 0 0.00159000235 0.001
+ 0.001590002375 0 0.0015900024 0.001 0.001590002425 0 0.00159000245 0.001 0.001590002475 0 0.0015900025 0.001 0.001590002525 0 0.00159000255 0.001
+ 0.001590002575 0 0.0015900026 0.001 0.001590002625 0 0.00159000265 0.001 0.001590002675 0 0.0015900027 0.001 0.001590002725 0 0.00159000275 0.001
+ 0.001590002775 0 0.0015900028 0.001 0.001590002825 0 0.00159000285 0.001 0.001590002875 0 0.0015900029 0.001 0.001590002925 0 0.00159000295 0.001
+ 0.001590002975 0 0.001590003 0.001 0.001599999 0 0.001599999025 0.001 0.00159999905 0 0.001599999075 0.001 0.0015999991 0 0.001599999125 0.001
+ 0.00159999915 0 0.001599999175 0.001 0.0015999992 0 0.001599999225 0.001 0.00159999925 0 0.001599999275 0.001 0.0015999993 0 0.001599999325 0.001
+ 0.00159999935 0 0.001599999375 0.001 0.0015999994 0 0.001599999425 0.001 0.00159999945 0 0.001599999475 0.001 0.0015999995 0 0.001599999525 0.001
+ 0.00159999955 0 0.001599999575 0.001 0.0015999996 0 0.001599999625 0.001 0.00159999965 0 0.001599999675 0.001 0.0015999997 0 0.001599999725 0.001
+ 0.00159999975 0 0.001599999775 0.001 0.0015999998 0 0.001599999825 0.001 0.00159999985 0 0.001599999875 0.001 0.0015999999 0 0.001599999925 0.001
+ 0.00159999995 0 0.001599999975 0.001 0.0016 0 0.001600000025 0.001 0.00160000005 0 0.001600000075 0.001 0.0016000001 0 0.001600000125 0.001
+ 0.00160000015 0 0.001600000175 0.001 0.0016000002 0 0.001600000225 0.001 0.00160000025 0 0.001600000275 0.001 0.0016000003 0 0.001600000325 0.001
+ 0.00160000035 0 0.001600000375 0.001 0.0016000004 0 0.001600000425 0.001 0.00160000045 0 0.001600000475 0.001 0.0016000005 0 0.001600000525 0.001
+ 0.00160000055 0 0.001600000575 0.001 0.0016000006 0 0.001600000625 0.001 0.00160000065 0 0.001600000675 0.001 0.0016000007 0 0.001600000725 0.001
+ 0.00160000075 0 0.001600000775 0.001 0.0016000008 0 0.001600000825 0.001 0.00160000085 0 0.001600000875 0.001 0.0016000009 0 0.001600000925 0.001
+ 0.00160000095 0 0.001600000975 0.001 0.001600001 0 0.001600001025 0.001 0.00160000105 0 0.001600001075 0.001 0.0016000011 0 0.001600001125 0.001
+ 0.00160000115 0 0.001600001175 0.001 0.0016000012 0 0.001600001225 0.001 0.00160000125 0 0.001600001275 0.001 0.0016000013 0 0.001600001325 0.001
+ 0.00160000135 0 0.001600001375 0.001 0.0016000014 0 0.001600001425 0.001 0.00160000145 0 0.001600001475 0.001 0.0016000015 0 0.001600001525 0.001
+ 0.00160000155 0 0.001600001575 0.001 0.0016000016 0 0.001600001625 0.001 0.00160000165 0 0.001600001675 0.001 0.0016000017 0 0.001600001725 0.001
+ 0.00160000175 0 0.001600001775 0.001 0.0016000018 0 0.001600001825 0.001 0.00160000185 0 0.001600001875 0.001 0.0016000019 0 0.001600001925 0.001
+ 0.00160000195 0 0.001600001975 0.001 0.001600002 0 0.001600002025 0.001 0.00160000205 0 0.001600002075 0.001 0.0016000021 0 0.001600002125 0.001
+ 0.00160000215 0 0.001600002175 0.001 0.0016000022 0 0.001600002225 0.001 0.00160000225 0 0.001600002275 0.001 0.0016000023 0 0.001600002325 0.001
+ 0.00160000235 0 0.001600002375 0.001 0.0016000024 0 0.001600002425 0.001 0.00160000245 0 0.001600002475 0.001 0.0016000025 0 0.001600002525 0.001
+ 0.00160000255 0 0.001600002575 0.001 0.0016000026 0 0.001600002625 0.001 0.00160000265 0 0.001600002675 0.001 0.0016000027 0 0.001600002725 0.001
+ 0.00160000275 0 0.001600002775 0.001 0.0016000028 0 0.001600002825 0.001 0.00160000285 0 0.001600002875 0.001 0.0016000029 0 0.001600002925 0.001
+ 0.00160000295 0 0.001600002975 0.001 0.001600003 0 0.001649999 0.001 0.001649999025 0 0.00164999905 0.001 0.001649999075 0 0.0016499991 0.001
+ 0.001649999125 0 0.00164999915 0.001 0.001649999175 0 0.0016499992 0.001 0.001649999225 0 0.00164999925 0.001 0.001649999275 0 0.0016499993 0.001
+ 0.001649999325 0 0.00164999935 0.001 0.001649999375 0 0.0016499994 0.001 0.001649999425 0 0.00164999945 0.001 0.001649999475 0 0.0016499995 0.001
+ 0.001649999525 0 0.00164999955 0.001 0.001649999575 0 0.0016499996 0.001 0.001649999625 0 0.00164999965 0.001 0.001649999675 0 0.0016499997 0.001
+ 0.001649999725 0 0.00164999975 0.001 0.001649999775 0 0.0016499998 0.001 0.001649999825 0 0.00164999985 0.001 0.001649999875 0 0.0016499999 0.001
+ 0.001649999925 0 0.00164999995 0.001 0.001649999975 0 0.00165 0.001 0.001650000025 0 0.00165000005 0.001 0.001650000075 0 0.0016500001 0.001
+ 0.001650000125 0 0.00165000015 0.001 0.001650000175 0 0.0016500002 0.001 0.001650000225 0 0.00165000025 0.001 0.001650000275 0 0.0016500003 0.001
+ 0.001650000325 0 0.00165000035 0.001 0.001650000375 0 0.0016500004 0.001 0.001650000425 0 0.00165000045 0.001 0.001650000475 0 0.0016500005 0.001
+ 0.001650000525 0 0.00165000055 0.001 0.001650000575 0 0.0016500006 0.001 0.001650000625 0 0.00165000065 0.001 0.001650000675 0 0.0016500007 0.001
+ 0.001650000725 0 0.00165000075 0.001 0.001650000775 0 0.0016500008 0.001 0.001650000825 0 0.00165000085 0.001 0.001650000875 0 0.0016500009 0.001
+ 0.001650000925 0 0.00165000095 0.001 0.001650000975 0 0.001650001 0.001 0.001650001025 0 0.00165000105 0.001 0.001650001075 0 0.0016500011 0.001
+ 0.001650001125 0 0.00165000115 0.001 0.001650001175 0 0.0016500012 0.001 0.001650001225 0 0.00165000125 0.001 0.001650001275 0 0.0016500013 0.001
+ 0.001650001325 0 0.00165000135 0.001 0.001650001375 0 0.0016500014 0.001 0.001650001425 0 0.00165000145 0.001 0.001650001475 0 0.0016500015 0.001
+ 0.001650001525 0 0.00165000155 0.001 0.001650001575 0 0.0016500016 0.001 0.001650001625 0 0.00165000165 0.001 0.001650001675 0 0.0016500017 0.001
+ 0.001650001725 0 0.00165000175 0.001 0.001650001775 0 0.0016500018 0.001 0.001650001825 0 0.00165000185 0.001 0.001650001875 0 0.0016500019 0.001
+ 0.001650001925 0 0.00165000195 0.001 0.001650001975 0 0.001650002 0.001 0.001650002025 0 0.00165000205 0.001 0.001650002075 0 0.0016500021 0.001
+ 0.001650002125 0 0.00165000215 0.001 0.001650002175 0 0.0016500022 0.001 0.001650002225 0 0.00165000225 0.001 0.001650002275 0 0.0016500023 0.001
+ 0.001650002325 0 0.00165000235 0.001 0.001650002375 0 0.0016500024 0.001 0.001650002425 0 0.00165000245 0.001 0.001650002475 0 0.0016500025 0.001
+ 0.001650002525 0 0.00165000255 0.001 0.001650002575 0 0.0016500026 0.001 0.001650002625 0 0.00165000265 0.001 0.001650002675 0 0.0016500027 0.001
+ 0.001650002725 0 0.00165000275 0.001 0.001650002775 0 0.0016500028 0.001 0.001650002825 0 0.00165000285 0.001 0.001650002875 0 0.0016500029 0.001
+ 0.001650002925 0 0.00165000295 0.001 0.001650002975 0 0.001650003 0.001 0.001649999 0 0.001649999025 0.001 0.00164999905 0 0.001649999075 0.001
+ 0.0016499991 0 0.001649999125 0.001 0.00164999915 0 0.001649999175 0.001 0.0016499992 0 0.001649999225 0.001 0.00164999925 0 0.001649999275 0.001
+ 0.0016499993 0 0.001649999325 0.001 0.00164999935 0 0.001649999375 0.001 0.0016499994 0 0.001649999425 0.001 0.00164999945 0 0.001649999475 0.001
+ 0.0016499995 0 0.001649999525 0.001 0.00164999955 0 0.001649999575 0.001 0.0016499996 0 0.001649999625 0.001 0.00164999965 0 0.001649999675 0.001
+ 0.0016499997 0 0.001649999725 0.001 0.00164999975 0 0.001649999775 0.001 0.0016499998 0 0.001649999825 0.001 0.00164999985 0 0.001649999875 0.001
+ 0.0016499999 0 0.001649999925 0.001 0.00164999995 0 0.001649999975 0.001 0.00165 0 0.001650000025 0.001 0.00165000005 0 0.001650000075 0.001
+ 0.0016500001 0 0.001650000125 0.001 0.00165000015 0 0.001650000175 0.001 0.0016500002 0 0.001650000225 0.001 0.00165000025 0 0.001650000275 0.001
+ 0.0016500003 0 0.001650000325 0.001 0.00165000035 0 0.001650000375 0.001 0.0016500004 0 0.001650000425 0.001 0.00165000045 0 0.001650000475 0.001
+ 0.0016500005 0 0.001650000525 0.001 0.00165000055 0 0.001650000575 0.001 0.0016500006 0 0.001650000625 0.001 0.00165000065 0 0.001650000675 0.001
+ 0.0016500007 0 0.001650000725 0.001 0.00165000075 0 0.001650000775 0.001 0.0016500008 0 0.001650000825 0.001 0.00165000085 0 0.001650000875 0.001
+ 0.0016500009 0 0.001650000925 0.001 0.00165000095 0 0.001650000975 0.001 0.001650001 0 0.001650001025 0.001 0.00165000105 0 0.001650001075 0.001
+ 0.0016500011 0 0.001650001125 0.001 0.00165000115 0 0.001650001175 0.001 0.0016500012 0 0.001650001225 0.001 0.00165000125 0 0.001650001275 0.001
+ 0.0016500013 0 0.001650001325 0.001 0.00165000135 0 0.001650001375 0.001 0.0016500014 0 0.001650001425 0.001 0.00165000145 0 0.001650001475 0.001
+ 0.0016500015 0 0.001650001525 0.001 0.00165000155 0 0.001650001575 0.001 0.0016500016 0 0.001650001625 0.001 0.00165000165 0 0.001650001675 0.001
+ 0.0016500017 0 0.001650001725 0.001 0.00165000175 0 0.001650001775 0.001 0.0016500018 0 0.001650001825 0.001 0.00165000185 0 0.001650001875 0.001
+ 0.0016500019 0 0.001650001925 0.001 0.00165000195 0 0.001650001975 0.001 0.001650002 0 0.001650002025 0.001 0.00165000205 0 0.001650002075 0.001
+ 0.0016500021 0 0.001650002125 0.001 0.00165000215 0 0.001650002175 0.001 0.0016500022 0 0.001650002225 0.001 0.00165000225 0 0.001650002275 0.001
+ 0.0016500023 0 0.001650002325 0.001 0.00165000235 0 0.001650002375 0.001 0.0016500024 0 0.001650002425 0.001 0.00165000245 0 0.001650002475 0.001
+ 0.0016500025 0 0.001650002525 0.001 0.00165000255 0 0.001650002575 0.001 0.0016500026 0 0.001650002625 0.001 0.00165000265 0 0.001650002675 0.001
+ 0.0016500027 0 0.001650002725 0.001 0.00165000275 0 0.001650002775 0.001 0.0016500028 0 0.001650002825 0.001 0.00165000285 0 0.001650002875 0.001
+ 0.0016500029 0 0.001650002925 0.001 0.00165000295 0 0.001650002975 0.001 0.001650003 0 0.001699999 0.001 0.001699999025 0 0.00169999905 0.001
+ 0.001699999075 0 0.0016999991 0.001 0.001699999125 0 0.00169999915 0.001 0.001699999175 0 0.0016999992 0.001 0.001699999225 0 0.00169999925 0.001
+ 0.001699999275 0 0.0016999993 0.001 0.001699999325 0 0.00169999935 0.001 0.001699999375 0 0.0016999994 0.001 0.001699999425 0 0.00169999945 0.001
+ 0.001699999475 0 0.0016999995 0.001 0.001699999525 0 0.00169999955 0.001 0.001699999575 0 0.0016999996 0.001 0.001699999625 0 0.00169999965 0.001
+ 0.001699999675 0 0.0016999997 0.001 0.001699999725 0 0.00169999975 0.001 0.001699999775 0 0.0016999998 0.001 0.001699999825 0 0.00169999985 0.001
+ 0.001699999875 0 0.0016999999 0.001 0.001699999925 0 0.00169999995 0.001 0.001699999975 0 0.0017 0.001 0.001700000025 0 0.00170000005 0.001
+ 0.001700000075 0 0.0017000001 0.001 0.001700000125 0 0.00170000015 0.001 0.001700000175 0 0.0017000002 0.001 0.001700000225 0 0.00170000025 0.001
+ 0.001700000275 0 0.0017000003 0.001 0.001700000325 0 0.00170000035 0.001 0.001700000375 0 0.0017000004 0.001 0.001700000425 0 0.00170000045 0.001
+ 0.001700000475 0 0.0017000005 0.001 0.001700000525 0 0.00170000055 0.001 0.001700000575 0 0.0017000006 0.001 0.001700000625 0 0.00170000065 0.001
+ 0.001700000675 0 0.0017000007 0.001 0.001700000725 0 0.00170000075 0.001 0.001700000775 0 0.0017000008 0.001 0.001700000825 0 0.00170000085 0.001
+ 0.001700000875 0 0.0017000009 0.001 0.001700000925 0 0.00170000095 0.001 0.001700000975 0 0.001700001 0.001 0.001700001025 0 0.00170000105 0.001
+ 0.001700001075 0 0.0017000011 0.001 0.001700001125 0 0.00170000115 0.001 0.001700001175 0 0.0017000012 0.001 0.001700001225 0 0.00170000125 0.001
+ 0.001700001275 0 0.0017000013 0.001 0.001700001325 0 0.00170000135 0.001 0.001700001375 0 0.0017000014 0.001 0.001700001425 0 0.00170000145 0.001
+ 0.001700001475 0 0.0017000015 0.001 0.001700001525 0 0.00170000155 0.001 0.001700001575 0 0.0017000016 0.001 0.001700001625 0 0.00170000165 0.001
+ 0.001700001675 0 0.0017000017 0.001 0.001700001725 0 0.00170000175 0.001 0.001700001775 0 0.0017000018 0.001 0.001700001825 0 0.00170000185 0.001
+ 0.001700001875 0 0.0017000019 0.001 0.001700001925 0 0.00170000195 0.001 0.001700001975 0 0.001700002 0.001 0.001700002025 0 0.00170000205 0.001
+ 0.001700002075 0 0.0017000021 0.001 0.001700002125 0 0.00170000215 0.001 0.001700002175 0 0.0017000022 0.001 0.001700002225 0 0.00170000225 0.001
+ 0.001700002275 0 0.0017000023 0.001 0.001700002325 0 0.00170000235 0.001 0.001700002375 0 0.0017000024 0.001 0.001700002425 0 0.00170000245 0.001
+ 0.001700002475 0 0.0017000025 0.001 0.001700002525 0 0.00170000255 0.001 0.001700002575 0 0.0017000026 0.001 0.001700002625 0 0.00170000265 0.001
+ 0.001700002675 0 0.0017000027 0.001 0.001700002725 0 0.00170000275 0.001 0.001700002775 0 0.0017000028 0.001 0.001700002825 0 0.00170000285 0.001
+ 0.001700002875 0 0.0017000029 0.001 0.001700002925 0 0.00170000295 0.001 0.001700002975 0 0.001700003 0.001 0.001749999 0 0.001749999025 0.001
+ 0.00174999905 0 0.001749999075 0.001 0.0017499991 0 0.001749999125 0.001 0.00174999915 0 0.001749999175 0.001 0.0017499992 0 0.001749999225 0.001
+ 0.00174999925 0 0.001749999275 0.001 0.0017499993 0 0.001749999325 0.001 0.00174999935 0 0.001749999375 0.001 0.0017499994 0 0.001749999425 0.001
+ 0.00174999945 0 0.001749999475 0.001 0.0017499995 0 0.001749999525 0.001 0.00174999955 0 0.001749999575 0.001 0.0017499996 0 0.001749999625 0.001
+ 0.00174999965 0 0.001749999675 0.001 0.0017499997 0 0.001749999725 0.001 0.00174999975 0 0.001749999775 0.001 0.0017499998 0 0.001749999825 0.001
+ 0.00174999985 0 0.001749999875 0.001 0.0017499999 0 0.001749999925 0.001 0.00174999995 0 0.001749999975 0.001 0.00175 0 0.001750000025 0.001
+ 0.00175000005 0 0.001750000075 0.001 0.0017500001 0 0.001750000125 0.001 0.00175000015 0 0.001750000175 0.001 0.0017500002 0 0.001750000225 0.001
+ 0.00175000025 0 0.001750000275 0.001 0.0017500003 0 0.001750000325 0.001 0.00175000035 0 0.001750000375 0.001 0.0017500004 0 0.001750000425 0.001
+ 0.00175000045 0 0.001750000475 0.001 0.0017500005 0 0.001750000525 0.001 0.00175000055 0 0.001750000575 0.001 0.0017500006 0 0.001750000625 0.001
+ 0.00175000065 0 0.001750000675 0.001 0.0017500007 0 0.001750000725 0.001 0.00175000075 0 0.001750000775 0.001 0.0017500008 0 0.001750000825 0.001
+ 0.00175000085 0 0.001750000875 0.001 0.0017500009 0 0.001750000925 0.001 0.00175000095 0 0.001750000975 0.001 0.001750001 0 0.001750001025 0.001
+ 0.00175000105 0 0.001750001075 0.001 0.0017500011 0 0.001750001125 0.001 0.00175000115 0 0.001750001175 0.001 0.0017500012 0 0.001750001225 0.001
+ 0.00175000125 0 0.001750001275 0.001 0.0017500013 0 0.001750001325 0.001 0.00175000135 0 0.001750001375 0.001 0.0017500014 0 0.001750001425 0.001
+ 0.00175000145 0 0.001750001475 0.001 0.0017500015 0 0.001750001525 0.001 0.00175000155 0 0.001750001575 0.001 0.0017500016 0 0.001750001625 0.001
+ 0.00175000165 0 0.001750001675 0.001 0.0017500017 0 0.001750001725 0.001 0.00175000175 0 0.001750001775 0.001 0.0017500018 0 0.001750001825 0.001
+ 0.00175000185 0 0.001750001875 0.001 0.0017500019 0 0.001750001925 0.001 0.00175000195 0 0.001750001975 0.001 0.001750002 0 0.001750002025 0.001
+ 0.00175000205 0 0.001750002075 0.001 0.0017500021 0 0.001750002125 0.001 0.00175000215 0 0.001750002175 0.001 0.0017500022 0 0.001750002225 0.001
+ 0.00175000225 0 0.001750002275 0.001 0.0017500023 0 0.001750002325 0.001 0.00175000235 0 0.001750002375 0.001 0.0017500024 0 0.001750002425 0.001
+ 0.00175000245 0 0.001750002475 0.001 0.0017500025 0 0.001750002525 0.001 0.00175000255 0 0.001750002575 0.001 0.0017500026 0 0.001750002625 0.001
+ 0.00175000265 0 0.001750002675 0.001 0.0017500027 0 0.001750002725 0.001 0.00175000275 0 0.001750002775 0.001 0.0017500028 0 0.001750002825 0.001
+ 0.00175000285 0 0.001750002875 0.001 0.0017500029 0 0.001750002925 0.001 0.00175000295 0 0.001750002975 0.001 0.001750003 0 0.001799999 0.001
+ 0.001799999025 0 0.00179999905 0.001 0.001799999075 0 0.0017999991 0.001 0.001799999125 0 0.00179999915 0.001 0.001799999175 0 0.0017999992 0.001
+ 0.001799999225 0 0.00179999925 0.001 0.001799999275 0 0.0017999993 0.001 0.001799999325 0 0.00179999935 0.001 0.001799999375 0 0.0017999994 0.001
+ 0.001799999425 0 0.00179999945 0.001 0.001799999475 0 0.0017999995 0.001 0.001799999525 0 0.00179999955 0.001 0.001799999575 0 0.0017999996 0.001
+ 0.001799999625 0 0.00179999965 0.001 0.001799999675 0 0.0017999997 0.001 0.001799999725 0 0.00179999975 0.001 0.001799999775 0 0.0017999998 0.001
+ 0.001799999825 0 0.00179999985 0.001 0.001799999875 0 0.0017999999 0.001 0.001799999925 0 0.00179999995 0.001 0.001799999975 0 0.0018 0.001
+ 0.001800000025 0 0.00180000005 0.001 0.001800000075 0 0.0018000001 0.001 0.001800000125 0 0.00180000015 0.001 0.001800000175 0 0.0018000002 0.001
+ 0.001800000225 0 0.00180000025 0.001 0.001800000275 0 0.0018000003 0.001 0.001800000325 0 0.00180000035 0.001 0.001800000375 0 0.0018000004 0.001
+ 0.001800000425 0 0.00180000045 0.001 0.001800000475 0 0.0018000005 0.001 0.001800000525 0 0.00180000055 0.001 0.001800000575 0 0.0018000006 0.001
+ 0.001800000625 0 0.00180000065 0.001 0.001800000675 0 0.0018000007 0.001 0.001800000725 0 0.00180000075 0.001 0.001800000775 0 0.0018000008 0.001
+ 0.001800000825 0 0.00180000085 0.001 0.001800000875 0 0.0018000009 0.001 0.001800000925 0 0.00180000095 0.001 0.001800000975 0 0.001800001 0.001
+ 0.001800001025 0 0.00180000105 0.001 0.001800001075 0 0.0018000011 0.001 0.001800001125 0 0.00180000115 0.001 0.001800001175 0 0.0018000012 0.001
+ 0.001800001225 0 0.00180000125 0.001 0.001800001275 0 0.0018000013 0.001 0.001800001325 0 0.00180000135 0.001 0.001800001375 0 0.0018000014 0.001
+ 0.001800001425 0 0.00180000145 0.001 0.001800001475 0 0.0018000015 0.001 0.001800001525 0 0.00180000155 0.001 0.001800001575 0 0.0018000016 0.001
+ 0.001800001625 0 0.00180000165 0.001 0.001800001675 0 0.0018000017 0.001 0.001800001725 0 0.00180000175 0.001 0.001800001775 0 0.0018000018 0.001
+ 0.001800001825 0 0.00180000185 0.001 0.001800001875 0 0.0018000019 0.001 0.001800001925 0 0.00180000195 0.001 0.001800001975 0 0.001800002 0.001
+ 0.001800002025 0 0.00180000205 0.001 0.001800002075 0 0.0018000021 0.001 0.001800002125 0 0.00180000215 0.001 0.001800002175 0 0.0018000022 0.001
+ 0.001800002225 0 0.00180000225 0.001 0.001800002275 0 0.0018000023 0.001 0.001800002325 0 0.00180000235 0.001 0.001800002375 0 0.0018000024 0.001
+ 0.001800002425 0 0.00180000245 0.001 0.001800002475 0 0.0018000025 0.001 0.001800002525 0 0.00180000255 0.001 0.001800002575 0 0.0018000026 0.001
+ 0.001800002625 0 0.00180000265 0.001 0.001800002675 0 0.0018000027 0.001 0.001800002725 0 0.00180000275 0.001 0.001800002775 0 0.0018000028 0.001
+ 0.001800002825 0 0.00180000285 0.001 0.001800002875 0 0.0018000029 0.001 0.001800002925 0 0.00180000295 0.001 0.001800002975 0 0.001800003 0.001
+ 0.001849999 0 0.001849999025 0.001 0.00184999905 0 0.001849999075 0.001 0.0018499991 0 0.001849999125 0.001 0.00184999915 0 0.001849999175 0.001
+ 0.0018499992 0 0.001849999225 0.001 0.00184999925 0 0.001849999275 0.001 0.0018499993 0 0.001849999325 0.001 0.00184999935 0 0.001849999375 0.001
+ 0.0018499994 0 0.001849999425 0.001 0.00184999945 0 0.001849999475 0.001 0.0018499995 0 0.001849999525 0.001 0.00184999955 0 0.001849999575 0.001
+ 0.0018499996 0 0.001849999625 0.001 0.00184999965 0 0.001849999675 0.001 0.0018499997 0 0.001849999725 0.001 0.00184999975 0 0.001849999775 0.001
+ 0.0018499998 0 0.001849999825 0.001 0.00184999985 0 0.001849999875 0.001 0.0018499999 0 0.001849999925 0.001 0.00184999995 0 0.001849999975 0.001
+ 0.00185 0 0.001850000025 0.001 0.00185000005 0 0.001850000075 0.001 0.0018500001 0 0.001850000125 0.001 0.00185000015 0 0.001850000175 0.001
+ 0.0018500002 0 0.001850000225 0.001 0.00185000025 0 0.001850000275 0.001 0.0018500003 0 0.001850000325 0.001 0.00185000035 0 0.001850000375 0.001
+ 0.0018500004 0 0.001850000425 0.001 0.00185000045 0 0.001850000475 0.001 0.0018500005 0 0.001850000525 0.001 0.00185000055 0 0.001850000575 0.001
+ 0.0018500006 0 0.001850000625 0.001 0.00185000065 0 0.001850000675 0.001 0.0018500007 0 0.001850000725 0.001 0.00185000075 0 0.001850000775 0.001
+ 0.0018500008 0 0.001850000825 0.001 0.00185000085 0 0.001850000875 0.001 0.0018500009 0 0.001850000925 0.001 0.00185000095 0 0.001850000975 0.001
+ 0.001850001 0 0.001850001025 0.001 0.00185000105 0 0.001850001075 0.001 0.0018500011 0 0.001850001125 0.001 0.00185000115 0 0.001850001175 0.001
+ 0.0018500012 0 0.001850001225 0.001 0.00185000125 0 0.001850001275 0.001 0.0018500013 0 0.001850001325 0.001 0.00185000135 0 0.001850001375 0.001
+ 0.0018500014 0 0.001850001425 0.001 0.00185000145 0 0.001850001475 0.001 0.0018500015 0 0.001850001525 0.001 0.00185000155 0 0.001850001575 0.001
+ 0.0018500016 0 0.001850001625 0.001 0.00185000165 0 0.001850001675 0.001 0.0018500017 0 0.001850001725 0.001 0.00185000175 0 0.001850001775 0.001
+ 0.0018500018 0 0.001850001825 0.001 0.00185000185 0 0.001850001875 0.001 0.0018500019 0 0.001850001925 0.001 0.00185000195 0 0.001850001975 0.001
+ 0.001850002 0 0.001850002025 0.001 0.00185000205 0 0.001850002075 0.001 0.0018500021 0 0.001850002125 0.001 0.00185000215 0 0.001850002175 0.001
+ 0.0018500022 0 0.001850002225 0.001 0.00185000225 0 0.001850002275 0.001 0.0018500023 0 0.001850002325 0.001 0.00185000235 0 0.001850002375 0.001
+ 0.0018500024 0 0.001850002425 0.001 0.00185000245 0 0.001850002475 0.001 0.0018500025 0 0.001850002525 0.001 0.00185000255 0 0.001850002575 0.001
+ 0.0018500026 0 0.001850002625 0.001 0.00185000265 0 0.001850002675 0.001 0.0018500027 0 0.001850002725 0.001 0.00185000275 0 0.001850002775 0.001
+ 0.0018500028 0 0.001850002825 0.001 0.00185000285 0 0.001850002875 0.001 0.0018500029 0 0.001850002925 0.001 0.00185000295 0 0.001850002975 0.001
+ 0.001850003 0 0.001889999 0.001 0.001889999025 0 0.00188999905 0.001 0.001889999075 0 0.0018899991 0.001 0.001889999125 0 0.00188999915 0.001
+ 0.001889999175 0 0.0018899992 0.001 0.001889999225 0 0.00188999925 0.001 0.001889999275 0 0.0018899993 0.001 0.001889999325 0 0.00188999935 0.001
+ 0.001889999375 0 0.0018899994 0.001 0.001889999425 0 0.00188999945 0.001 0.001889999475 0 0.0018899995 0.001 0.001889999525 0 0.00188999955 0.001
+ 0.001889999575 0 0.0018899996 0.001 0.001889999625 0 0.00188999965 0.001 0.001889999675 0 0.0018899997 0.001 0.001889999725 0 0.00188999975 0.001
+ 0.001889999775 0 0.0018899998 0.001 0.001889999825 0 0.00188999985 0.001 0.001889999875 0 0.0018899999 0.001 0.001889999925 0 0.00188999995 0.001
+ 0.001889999975 0 0.00189 0.001 0.001890000025 0 0.00189000005 0.001 0.001890000075 0 0.0018900001 0.001 0.001890000125 0 0.00189000015 0.001
+ 0.001890000175 0 0.0018900002 0.001 0.001890000225 0 0.00189000025 0.001 0.001890000275 0 0.0018900003 0.001 0.001890000325 0 0.00189000035 0.001
+ 0.001890000375 0 0.0018900004 0.001 0.001890000425 0 0.00189000045 0.001 0.001890000475 0 0.0018900005 0.001 0.001890000525 0 0.00189000055 0.001
+ 0.001890000575 0 0.0018900006 0.001 0.001890000625 0 0.00189000065 0.001 0.001890000675 0 0.0018900007 0.001 0.001890000725 0 0.00189000075 0.001
+ 0.001890000775 0 0.0018900008 0.001 0.001890000825 0 0.00189000085 0.001 0.001890000875 0 0.0018900009 0.001 0.001890000925 0 0.00189000095 0.001
+ 0.001890000975 0 0.001890001 0.001 0.001890001025 0 0.00189000105 0.001 0.001890001075 0 0.0018900011 0.001 0.001890001125 0 0.00189000115 0.001
+ 0.001890001175 0 0.0018900012 0.001 0.001890001225 0 0.00189000125 0.001 0.001890001275 0 0.0018900013 0.001 0.001890001325 0 0.00189000135 0.001
+ 0.001890001375 0 0.0018900014 0.001 0.001890001425 0 0.00189000145 0.001 0.001890001475 0 0.0018900015 0.001 0.001890001525 0 0.00189000155 0.001
+ 0.001890001575 0 0.0018900016 0.001 0.001890001625 0 0.00189000165 0.001 0.001890001675 0 0.0018900017 0.001 0.001890001725 0 0.00189000175 0.001
+ 0.001890001775 0 0.0018900018 0.001 0.001890001825 0 0.00189000185 0.001 0.001890001875 0 0.0018900019 0.001 0.001890001925 0 0.00189000195 0.001
+ 0.001890001975 0 0.001890002 0.001 0.001890002025 0 0.00189000205 0.001 0.001890002075 0 0.0018900021 0.001 0.001890002125 0 0.00189000215 0.001
+ 0.001890002175 0 0.0018900022 0.001 0.001890002225 0 0.00189000225 0.001 0.001890002275 0 0.0018900023 0.001 0.001890002325 0 0.00189000235 0.001
+ 0.001890002375 0 0.0018900024 0.001 0.001890002425 0 0.00189000245 0.001 0.001890002475 0 0.0018900025 0.001 0.001890002525 0 0.00189000255 0.001
+ 0.001890002575 0 0.0018900026 0.001 0.001890002625 0 0.00189000265 0.001 0.001890002675 0 0.0018900027 0.001 0.001890002725 0 0.00189000275 0.001
+ 0.001890002775 0 0.0018900028 0.001 0.001890002825 0 0.00189000285 0.001 0.001890002875 0 0.0018900029 0.001 0.001890002925 0 0.00189000295 0.001
+ 0.001890002975 0 0.001890003 0.001 0.001899999 0 0.001899999025 0.001 0.00189999905 0 0.001899999075 0.001 0.0018999991 0 0.001899999125 0.001
+ 0.00189999915 0 0.001899999175 0.001 0.0018999992 0 0.001899999225 0.001 0.00189999925 0 0.001899999275 0.001 0.0018999993 0 0.001899999325 0.001
+ 0.00189999935 0 0.001899999375 0.001 0.0018999994 0 0.001899999425 0.001 0.00189999945 0 0.001899999475 0.001 0.0018999995 0 0.001899999525 0.001
+ 0.00189999955 0 0.001899999575 0.001 0.0018999996 0 0.001899999625 0.001 0.00189999965 0 0.001899999675 0.001 0.0018999997 0 0.001899999725 0.001
+ 0.00189999975 0 0.001899999775 0.001 0.0018999998 0 0.001899999825 0.001 0.00189999985 0 0.001899999875 0.001 0.0018999999 0 0.001899999925 0.001
+ 0.00189999995 0 0.001899999975 0.001 0.0019 0 0.001900000025 0.001 0.00190000005 0 0.001900000075 0.001 0.0019000001 0 0.001900000125 0.001
+ 0.00190000015 0 0.001900000175 0.001 0.0019000002 0 0.001900000225 0.001 0.00190000025 0 0.001900000275 0.001 0.0019000003 0 0.001900000325 0.001
+ 0.00190000035 0 0.001900000375 0.001 0.0019000004 0 0.001900000425 0.001 0.00190000045 0 0.001900000475 0.001 0.0019000005 0 0.001900000525 0.001
+ 0.00190000055 0 0.001900000575 0.001 0.0019000006 0 0.001900000625 0.001 0.00190000065 0 0.001900000675 0.001 0.0019000007 0 0.001900000725 0.001
+ 0.00190000075 0 0.001900000775 0.001 0.0019000008 0 0.001900000825 0.001 0.00190000085 0 0.001900000875 0.001 0.0019000009 0 0.001900000925 0.001
+ 0.00190000095 0 0.001900000975 0.001 0.001900001 0 0.001900001025 0.001 0.00190000105 0 0.001900001075 0.001 0.0019000011 0 0.001900001125 0.001
+ 0.00190000115 0 0.001900001175 0.001 0.0019000012 0 0.001900001225 0.001 0.00190000125 0 0.001900001275 0.001 0.0019000013 0 0.001900001325 0.001
+ 0.00190000135 0 0.001900001375 0.001 0.0019000014 0 0.001900001425 0.001 0.00190000145 0 0.001900001475 0.001 0.0019000015 0 0.001900001525 0.001
+ 0.00190000155 0 0.001900001575 0.001 0.0019000016 0 0.001900001625 0.001 0.00190000165 0 0.001900001675 0.001 0.0019000017 0 0.001900001725 0.001
+ 0.00190000175 0 0.001900001775 0.001 0.0019000018 0 0.001900001825 0.001 0.00190000185 0 0.001900001875 0.001 0.0019000019 0 0.001900001925 0.001
+ 0.00190000195 0 0.001900001975 0.001 0.001900002 0 0.001900002025 0.001 0.00190000205 0 0.001900002075 0.001 0.0019000021 0 0.001900002125 0.001
+ 0.00190000215 0 0.001900002175 0.001 0.0019000022 0 0.001900002225 0.001 0.00190000225 0 0.001900002275 0.001 0.0019000023 0 0.001900002325 0.001
+ 0.00190000235 0 0.001900002375 0.001 0.0019000024 0 0.001900002425 0.001 0.00190000245 0 0.001900002475 0.001 0.0019000025 0 0.001900002525 0.001
+ 0.00190000255 0 0.001900002575 0.001 0.0019000026 0 0.001900002625 0.001 0.00190000265 0 0.001900002675 0.001 0.0019000027 0 0.001900002725 0.001
+ 0.00190000275 0 0.001900002775 0.001 0.0019000028 0 0.001900002825 0.001 0.00190000285 0 0.001900002875 0.001 0.0019000029 0 0.001900002925 0.001
+ 0.00190000295 0 0.001900002975 0.001 0.001900003 0 0.001949999 0.001 0.001949999025 0 0.00194999905 0.001 0.001949999075 0 0.0019499991 0.001
+ 0.001949999125 0 0.00194999915 0.001 0.001949999175 0 0.0019499992 0.001 0.001949999225 0 0.00194999925 0.001 0.001949999275 0 0.0019499993 0.001
+ 0.001949999325 0 0.00194999935 0.001 0.001949999375 0 0.0019499994 0.001 0.001949999425 0 0.00194999945 0.001 0.001949999475 0 0.0019499995 0.001
+ 0.001949999525 0 0.00194999955 0.001 0.001949999575 0 0.0019499996 0.001 0.001949999625 0 0.00194999965 0.001 0.001949999675 0 0.0019499997 0.001
+ 0.001949999725 0 0.00194999975 0.001 0.001949999775 0 0.0019499998 0.001 0.001949999825 0 0.00194999985 0.001 0.001949999875 0 0.0019499999 0.001
+ 0.001949999925 0 0.00194999995 0.001 0.001949999975 0 0.00195 0.001 0.001950000025 0 0.00195000005 0.001 0.001950000075 0 0.0019500001 0.001
+ 0.001950000125 0 0.00195000015 0.001 0.001950000175 0 0.0019500002 0.001 0.001950000225 0 0.00195000025 0.001 0.001950000275 0 0.0019500003 0.001
+ 0.001950000325 0 0.00195000035 0.001 0.001950000375 0 0.0019500004 0.001 0.001950000425 0 0.00195000045 0.001 0.001950000475 0 0.0019500005 0.001
+ 0.001950000525 0 0.00195000055 0.001 0.001950000575 0 0.0019500006 0.001 0.001950000625 0 0.00195000065 0.001 0.001950000675 0 0.0019500007 0.001
+ 0.001950000725 0 0.00195000075 0.001 0.001950000775 0 0.0019500008 0.001 0.001950000825 0 0.00195000085 0.001 0.001950000875 0 0.0019500009 0.001
+ 0.001950000925 0 0.00195000095 0.001 0.001950000975 0 0.001950001 0.001 0.001950001025 0 0.00195000105 0.001 0.001950001075 0 0.0019500011 0.001
+ 0.001950001125 0 0.00195000115 0.001 0.001950001175 0 0.0019500012 0.001 0.001950001225 0 0.00195000125 0.001 0.001950001275 0 0.0019500013 0.001
+ 0.001950001325 0 0.00195000135 0.001 0.001950001375 0 0.0019500014 0.001 0.001950001425 0 0.00195000145 0.001 0.001950001475 0 0.0019500015 0.001
+ 0.001950001525 0 0.00195000155 0.001 0.001950001575 0 0.0019500016 0.001 0.001950001625 0 0.00195000165 0.001 0.001950001675 0 0.0019500017 0.001
+ 0.001950001725 0 0.00195000175 0.001 0.001950001775 0 0.0019500018 0.001 0.001950001825 0 0.00195000185 0.001 0.001950001875 0 0.0019500019 0.001
+ 0.001950001925 0 0.00195000195 0.001 0.001950001975 0 0.001950002 0.001 0.001950002025 0 0.00195000205 0.001 0.001950002075 0 0.0019500021 0.001
+ 0.001950002125 0 0.00195000215 0.001 0.001950002175 0 0.0019500022 0.001 0.001950002225 0 0.00195000225 0.001 0.001950002275 0 0.0019500023 0.001
+ 0.001950002325 0 0.00195000235 0.001 0.001950002375 0 0.0019500024 0.001 0.001950002425 0 0.00195000245 0.001 0.001950002475 0 0.0019500025 0.001
+ 0.001950002525 0 0.00195000255 0.001 0.001950002575 0 0.0019500026 0.001 0.001950002625 0 0.00195000265 0.001 0.001950002675 0 0.0019500027 0.001
+ 0.001950002725 0 0.00195000275 0.001 0.001950002775 0 0.0019500028 0.001 0.001950002825 0 0.00195000285 0.001 0.001950002875 0 0.0019500029 0.001
+ 0.001950002925 0 0.00195000295 0.001 0.001950002975 0 0.001950003 0.001 0.00195 0 0.001950000025 0.001 0.00195000005 0 0.001950000075 0.001
+ 0.0019500001 0 0.001950000125 0.001 0.00195000015 0 0.001950000175 0.001 0.0019500002 0 0.001950000225 0.001 0.00195000025 0 0.001950000275 0.001
+ 0.0019500003 0 0.001950000325 0.001 0.00195000035 0 0.001950000375 0.001 0.0019500004 0 0.001950000425 0.001 0.00195000045 0 0.001950000475 0.001
+ 0.0019500005 0 0.001950000525 0.001 0.00195000055 0 0.001950000575 0.001 0.0019500006 0 0.001950000625 0.001 0.00195000065 0 0.001950000675 0.001
+ 0.0019500007 0 0.001950000725 0.001 0.00195000075 0 0.001950000775 0.001 0.0019500008 0 0.001950000825 0.001 0.00195000085 0 0.001950000875 0.001
+ 0.0019500009 0 0.001950000925 0.001 0.00195000095 0 0.001950000975 0.001 0.001950001 0 0.001950001025 0.001 0.00195000105 0 0.001950001075 0.001
+ 0.0019500011 0 0.001950001125 0.001 0.00195000115 0 0.001950001175 0.001 0.0019500012 0 0.001950001225 0.001 0.00195000125 0 0.001950001275 0.001
+ 0.0019500013 0 0.001950001325 0.001 0.00195000135 0 0.001950001375 0.001 0.0019500014 0 0.001950001425 0.001 0.00195000145 0 0.001950001475 0.001
+ 0.0019500015 0 0.001950001525 0.001 0.00195000155 0 0.001950001575 0.001 0.0019500016 0 0.001950001625 0.001 0.00195000165 0 0.001950001675 0.001
+ 0.0019500017 0 0.001950001725 0.001 0.00195000175 0 0.001950001775 0.001 0.0019500018 0 0.001950001825 0.001 0.00195000185 0 0.001950001875 0.001
+ 0.0019500019 0 0.001950001925 0.001 0.00195000195 0 0.001950001975 0.001 0.001950002 0 0.001950002025 0.001 0.00195000205 0 0.001950002075 0.001
+ 0.0019500021 0 0.001950002125 0.001 0.00195000215 0 0.001950002175 0.001 0.0019500022 0 0.001950002225 0.001 0.00195000225 0 0.001950002275 0.001
+ 0.0019500023 0 0.001950002325 0.001 0.00195000235 0 0.001950002375 0.001 0.0019500024 0 0.001950002425 0.001 0.00195000245 0 0.001950002475 0.001
+ 0.0019500025 0 0.001950002525 0.001 0.00195000255 0 0.001950002575 0.001 0.0019500026 0 0.001950002625 0.001 0.00195000265 0 0.001950002675 0.001
+ 0.0019500027 0 0.001950002725 0.001 0.00195000275 0 0.001950002775 0.001 0.0019500028 0 0.001950002825 0.001 0.00195000285 0 0.001950002875 0.001
+ 0.0019500029 0 0.001950002925 0.001 0.00195000295 0 0.001950002975 0.001 0.001950003 0 0.001950003025 0.001 0.00195000305 0 0.001950003075 0.001
+ 0.0019500031 0 0.001950003125 0.001 0.00195000315 0 0.001950003175 0.001 0.0019500032 0 0.001950003225 0.001 0.00195000325 0 0.001950003275 0.001
+ 0.0019500033 0 0.001950003325 0.001 0.00195000335 0 0.001950003375 0.001 0.0019500034 0 0.001950003425 0.001 0.00195000345 0 0.001950003475 0.001
+ 0.0019500035 0 0.001950003525 0.001 0.00195000355 0 0.001950003575 0.001 0.0019500036 0 0.001950003625 0.001 0.00195000365 0 0.001950003675 0.001
+ 0.0019500037 0 0.001950003725 0.001 0.00195000375 0 0.001950003775 0.001 0.0019500038 0 0.001950003825 0.001 0.00195000385 0 0.001950003875 0.001
+ 0.0019500039 0 0.001950003925 0.001 0.00195000395 0 0.001950003975 0.001 0.001950004 0 0.001999999 0.001 0.001999999025 0 0.00199999905 0.001
+ 0.001999999075 0 0.0019999991 0.001 0.001999999125 0 0.00199999915 0.001 0.001999999175 0 0.0019999992 0.001 0.001999999225 0 0.00199999925 0.001
+ 0.001999999275 0 0.0019999993 0.001 0.001999999325 0 0.00199999935 0.001 0.001999999375 0 0.0019999994 0.001 0.001999999425 0 0.00199999945 0.001
+ 0.001999999475 0 0.0019999995 0.001 0.001999999525 0 0.00199999955 0.001 0.001999999575 0 0.0019999996 0.001 0.001999999625 0 0.00199999965 0.001
+ 0.001999999675 0 0.0019999997 0.001 0.001999999725 0 0.00199999975 0.001 0.001999999775 0 0.0019999998 0.001 0.001999999825 0 0.00199999985 0.001
+ 0.001999999875 0 0.0019999999 0.001 0.001999999925 0 0.00199999995 0.001 0.001999999975 0 0.002 0.001 0.002000000025 0 0.00200000005 0.001
+ 0.002000000075 0 0.0020000001 0.001 0.002000000125 0 0.00200000015 0.001 0.002000000175 0 0.0020000002 0.001 0.002000000225 0 0.00200000025 0.001
+ 0.002000000275 0 0.0020000003 0.001 0.002000000325 0 0.00200000035 0.001 0.002000000375 0 0.0020000004 0.001 0.002000000425 0 0.00200000045 0.001
+ 0.002000000475 0 0.0020000005 0.001 0.002000000525 0 0.00200000055 0.001 0.002000000575 0 0.0020000006 0.001 0.002000000625 0 0.00200000065 0.001
+ 0.002000000675 0 0.0020000007 0.001 0.002000000725 0 0.00200000075 0.001 0.002000000775 0 0.0020000008 0.001 0.002000000825 0 0.00200000085 0.001
+ 0.002000000875 0 0.0020000009 0.001 0.002000000925 0 0.00200000095 0.001 0.002000000975 0 0.002000001 0.001 0.002000001025 0 0.00200000105 0.001
+ 0.002000001075 0 0.0020000011 0.001 0.002000001125 0 0.00200000115 0.001 0.002000001175 0 0.0020000012 0.001 0.002000001225 0 0.00200000125 0.001
+ 0.002000001275 0 0.0020000013 0.001 0.002000001325 0 0.00200000135 0.001 0.002000001375 0 0.0020000014 0.001 0.002000001425 0 0.00200000145 0.001
+ 0.002000001475 0 0.0020000015 0.001 0.002000001525 0 0.00200000155 0.001 0.002000001575 0 0.0020000016 0.001 0.002000001625 0 0.00200000165 0.001
+ 0.002000001675 0 0.0020000017 0.001 0.002000001725 0 0.00200000175 0.001 0.002000001775 0 0.0020000018 0.001 0.002000001825 0 0.00200000185 0.001
+ 0.002000001875 0 0.0020000019 0.001 0.002000001925 0 0.00200000195 0.001 0.002000001975 0 0.002000002 0.001 0.002000002025 0 0.00200000205 0.001
+ 0.002000002075 0 0.0020000021 0.001 0.002000002125 0 0.00200000215 0.001 0.002000002175 0 0.0020000022 0.001 0.002000002225 0 0.00200000225 0.001
+ 0.002000002275 0 0.0020000023 0.001 0.002000002325 0 0.00200000235 0.001 0.002000002375 0 0.0020000024 0.001 0.002000002425 0 0.00200000245 0.001
+ 0.002000002475 0 0.0020000025 0.001 0.002000002525 0 0.00200000255 0.001 0.002000002575 0 0.0020000026 0.001 0.002000002625 0 0.00200000265 0.001
+ 0.002000002675 0 0.0020000027 0.001 0.002000002725 0 0.00200000275 0.001 0.002000002775 0 0.0020000028 0.001 0.002000002825 0 0.00200000285 0.001
+ 0.002000002875 0 0.0020000029 0.001 0.002000002925 0 0.00200000295 0.001 0.002000002975 0 0.002000003 0.001 0.002049999 0 0.002049999025 0.001
+ 0.00204999905 0 0.002049999075 0.001 0.0020499991 0 0.002049999125 0.001 0.00204999915 0 0.002049999175 0.001 0.0020499992 0 0.002049999225 0.001
+ 0.00204999925 0 0.002049999275 0.001 0.0020499993 0 0.002049999325 0.001 0.00204999935 0 0.002049999375 0.001 0.0020499994 0 0.002049999425 0.001
+ 0.00204999945 0 0.002049999475 0.001 0.0020499995 0 0.002049999525 0.001 0.00204999955 0 0.002049999575 0.001 0.0020499996 0 0.002049999625 0.001
+ 0.00204999965 0 0.002049999675 0.001 0.0020499997 0 0.002049999725 0.001 0.00204999975 0 0.002049999775 0.001 0.0020499998 0 0.002049999825 0.001
+ 0.00204999985 0 0.002049999875 0.001 0.0020499999 0 0.002049999925 0.001 0.00204999995 0 0.002049999975 0.001 0.00205 0 0.002050000025 0.001
+ 0.00205000005 0 0.002050000075 0.001 0.0020500001 0 0.002050000125 0.001 0.00205000015 0 0.002050000175 0.001 0.0020500002 0 0.002050000225 0.001
+ 0.00205000025 0 0.002050000275 0.001 0.0020500003 0 0.002050000325 0.001 0.00205000035 0 0.002050000375 0.001 0.0020500004 0 0.002050000425 0.001
+ 0.00205000045 0 0.002050000475 0.001 0.0020500005 0 0.002050000525 0.001 0.00205000055 0 0.002050000575 0.001 0.0020500006 0 0.002050000625 0.001
+ 0.00205000065 0 0.002050000675 0.001 0.0020500007 0 0.002050000725 0.001 0.00205000075 0 0.002050000775 0.001 0.0020500008 0 0.002050000825 0.001
+ 0.00205000085 0 0.002050000875 0.001 0.0020500009 0 0.002050000925 0.001 0.00205000095 0 0.002050000975 0.001 0.002050001 0 0.002050001025 0.001
+ 0.00205000105 0 0.002050001075 0.001 0.0020500011 0 0.002050001125 0.001 0.00205000115 0 0.002050001175 0.001 0.0020500012 0 0.002050001225 0.001
+ 0.00205000125 0 0.002050001275 0.001 0.0020500013 0 0.002050001325 0.001 0.00205000135 0 0.002050001375 0.001 0.0020500014 0 0.002050001425 0.001
+ 0.00205000145 0 0.002050001475 0.001 0.0020500015 0 0.002050001525 0.001 0.00205000155 0 0.002050001575 0.001 0.0020500016 0 0.002050001625 0.001
+ 0.00205000165 0 0.002050001675 0.001 0.0020500017 0 0.002050001725 0.001 0.00205000175 0 0.002050001775 0.001 0.0020500018 0 0.002050001825 0.001
+ 0.00205000185 0 0.002050001875 0.001 0.0020500019 0 0.002050001925 0.001 0.00205000195 0 0.002050001975 0.001 0.002050002 0 0.002050002025 0.001
+ 0.00205000205 0 0.002050002075 0.001 0.0020500021 0 0.002050002125 0.001 0.00205000215 0 0.002050002175 0.001 0.0020500022 0 0.002050002225 0.001
+ 0.00205000225 0 0.002050002275 0.001 0.0020500023 0 0.002050002325 0.001 0.00205000235 0 0.002050002375 0.001 0.0020500024 0 0.002050002425 0.001
+ 0.00205000245 0 0.002050002475 0.001 0.0020500025 0 0.002050002525 0.001 0.00205000255 0 0.002050002575 0.001 0.0020500026 0 0.002050002625 0.001
+ 0.00205000265 0 0.002050002675 0.001 0.0020500027 0 0.002050002725 0.001 0.00205000275 0 0.002050002775 0.001 0.0020500028 0 0.002050002825 0.001
+ 0.00205000285 0 0.002050002875 0.001 0.0020500029 0 0.002050002925 0.001 0.00205000295 0 0.002050002975 0.001 0.002050003 0 0.002099999 0.001
+ 0.002099999025 0 0.00209999905 0.001 0.002099999075 0 0.0020999991 0.001 0.002099999125 0 0.00209999915 0.001 0.002099999175 0 0.0020999992 0.001
+ 0.002099999225 0 0.00209999925 0.001 0.002099999275 0 0.0020999993 0.001 0.002099999325 0 0.00209999935 0.001 0.002099999375 0 0.0020999994 0.001
+ 0.002099999425 0 0.00209999945 0.001 0.002099999475 0 0.0020999995 0.001 0.002099999525 0 0.00209999955 0.001 0.002099999575 0 0.0020999996 0.001
+ 0.002099999625 0 0.00209999965 0.001 0.002099999675 0 0.0020999997 0.001 0.002099999725 0 0.00209999975 0.001 0.002099999775 0 0.0020999998 0.001
+ 0.002099999825 0 0.00209999985 0.001 0.002099999875 0 0.0020999999 0.001 0.002099999925 0 0.00209999995 0.001 0.002099999975 0 0.0021 0.001
+ 0.002100000025 0 0.00210000005 0.001 0.002100000075 0 0.0021000001 0.001 0.002100000125 0 0.00210000015 0.001 0.002100000175 0 0.0021000002 0.001
+ 0.002100000225 0 0.00210000025 0.001 0.002100000275 0 0.0021000003 0.001 0.002100000325 0 0.00210000035 0.001 0.002100000375 0 0.0021000004 0.001
+ 0.002100000425 0 0.00210000045 0.001 0.002100000475 0 0.0021000005 0.001 0.002100000525 0 0.00210000055 0.001 0.002100000575 0 0.0021000006 0.001
+ 0.002100000625 0 0.00210000065 0.001 0.002100000675 0 0.0021000007 0.001 0.002100000725 0 0.00210000075 0.001 0.002100000775 0 0.0021000008 0.001
+ 0.002100000825 0 0.00210000085 0.001 0.002100000875 0 0.0021000009 0.001 0.002100000925 0 0.00210000095 0.001 0.002100000975 0 0.002100001 0.001
+ 0.002100001025 0 0.00210000105 0.001 0.002100001075 0 0.0021000011 0.001 0.002100001125 0 0.00210000115 0.001 0.002100001175 0 0.0021000012 0.001
+ 0.002100001225 0 0.00210000125 0.001 0.002100001275 0 0.0021000013 0.001 0.002100001325 0 0.00210000135 0.001 0.002100001375 0 0.0021000014 0.001
+ 0.002100001425 0 0.00210000145 0.001 0.002100001475 0 0.0021000015 0.001 0.002100001525 0 0.00210000155 0.001 0.002100001575 0 0.0021000016 0.001
+ 0.002100001625 0 0.00210000165 0.001 0.002100001675 0 0.0021000017 0.001 0.002100001725 0 0.00210000175 0.001 0.002100001775 0 0.0021000018 0.001
+ 0.002100001825 0 0.00210000185 0.001 0.002100001875 0 0.0021000019 0.001 0.002100001925 0 0.00210000195 0.001 0.002100001975 0 0.002100002 0.001
+ 0.002100002025 0 0.00210000205 0.001 0.002100002075 0 0.0021000021 0.001 0.002100002125 0 0.00210000215 0.001 0.002100002175 0 0.0021000022 0.001
+ 0.002100002225 0 0.00210000225 0.001 0.002100002275 0 0.0021000023 0.001 0.002100002325 0 0.00210000235 0.001 0.002100002375 0 0.0021000024 0.001
+ 0.002100002425 0 0.00210000245 0.001 0.002100002475 0 0.0021000025 0.001 0.002100002525 0 0.00210000255 0.001 0.002100002575 0 0.0021000026 0.001
+ 0.002100002625 0 0.00210000265 0.001 0.002100002675 0 0.0021000027 0.001 0.002100002725 0 0.00210000275 0.001 0.002100002775 0 0.0021000028 0.001
+ 0.002100002825 0 0.00210000285 0.001 0.002100002875 0 0.0021000029 0.001 0.002100002925 0 0.00210000295 0.001 0.002100002975 0 0.002100003 0.001
+ 0.002149999 0 0.002149999025 0.001 0.00214999905 0 0.002149999075 0.001 0.0021499991 0 0.002149999125 0.001 0.00214999915 0 0.002149999175 0.001
+ 0.0021499992 0 0.002149999225 0.001 0.00214999925 0 0.002149999275 0.001 0.0021499993 0 0.002149999325 0.001 0.00214999935 0 0.002149999375 0.001
+ 0.0021499994 0 0.002149999425 0.001 0.00214999945 0 0.002149999475 0.001 0.0021499995 0 0.002149999525 0.001 0.00214999955 0 0.002149999575 0.001
+ 0.0021499996 0 0.002149999625 0.001 0.00214999965 0 0.002149999675 0.001 0.0021499997 0 0.002149999725 0.001 0.00214999975 0 0.002149999775 0.001
+ 0.0021499998 0 0.002149999825 0.001 0.00214999985 0 0.002149999875 0.001 0.0021499999 0 0.002149999925 0.001 0.00214999995 0 0.002149999975 0.001
+ 0.00215 0 0.002150000025 0.001 0.00215000005 0 0.002150000075 0.001 0.0021500001 0 0.002150000125 0.001 0.00215000015 0 0.002150000175 0.001
+ 0.0021500002 0 0.002150000225 0.001 0.00215000025 0 0.002150000275 0.001 0.0021500003 0 0.002150000325 0.001 0.00215000035 0 0.002150000375 0.001
+ 0.0021500004 0 0.002150000425 0.001 0.00215000045 0 0.002150000475 0.001 0.0021500005 0 0.002150000525 0.001 0.00215000055 0 0.002150000575 0.001
+ 0.0021500006 0 0.002150000625 0.001 0.00215000065 0 0.002150000675 0.001 0.0021500007 0 0.002150000725 0.001 0.00215000075 0 0.002150000775 0.001
+ 0.0021500008 0 0.002150000825 0.001 0.00215000085 0 0.002150000875 0.001 0.0021500009 0 0.002150000925 0.001 0.00215000095 0 0.002150000975 0.001
+ 0.002150001 0 0.002150001025 0.001 0.00215000105 0 0.002150001075 0.001 0.0021500011 0 0.002150001125 0.001 0.00215000115 0 0.002150001175 0.001
+ 0.0021500012 0 0.002150001225 0.001 0.00215000125 0 0.002150001275 0.001 0.0021500013 0 0.002150001325 0.001 0.00215000135 0 0.002150001375 0.001
+ 0.0021500014 0 0.002150001425 0.001 0.00215000145 0 0.002150001475 0.001 0.0021500015 0 0.002150001525 0.001 0.00215000155 0 0.002150001575 0.001
+ 0.0021500016 0 0.002150001625 0.001 0.00215000165 0 0.002150001675 0.001 0.0021500017 0 0.002150001725 0.001 0.00215000175 0 0.002150001775 0.001
+ 0.0021500018 0 0.002150001825 0.001 0.00215000185 0 0.002150001875 0.001 0.0021500019 0 0.002150001925 0.001 0.00215000195 0 0.002150001975 0.001
+ 0.002150002 0 0.002150002025 0.001 0.00215000205 0 0.002150002075 0.001 0.0021500021 0 0.002150002125 0.001 0.00215000215 0 0.002150002175 0.001
+ 0.0021500022 0 0.002150002225 0.001 0.00215000225 0 0.002150002275 0.001 0.0021500023 0 0.002150002325 0.001 0.00215000235 0 0.002150002375 0.001
+ 0.0021500024 0 0.002150002425 0.001 0.00215000245 0 0.002150002475 0.001 0.0021500025 0 0.002150002525 0.001 0.00215000255 0 0.002150002575 0.001
+ 0.0021500026 0 0.002150002625 0.001 0.00215000265 0 0.002150002675 0.001 0.0021500027 0 0.002150002725 0.001 0.00215000275 0 0.002150002775 0.001
+ 0.0021500028 0 0.002150002825 0.001 0.00215000285 0 0.002150002875 0.001 0.0021500029 0 0.002150002925 0.001 0.00215000295 0 0.002150002975 0.001
+ 0.002150003 0 0.002189999 0.001 0.002189999025 0 0.00218999905 0.001 0.002189999075 0 0.0021899991 0.001 0.002189999125 0 0.00218999915 0.001
+ 0.002189999175 0 0.0021899992 0.001 0.002189999225 0 0.00218999925 0.001 0.002189999275 0 0.0021899993 0.001 0.002189999325 0 0.00218999935 0.001
+ 0.002189999375 0 0.0021899994 0.001 0.002189999425 0 0.00218999945 0.001 0.002189999475 0 0.0021899995 0.001 0.002189999525 0 0.00218999955 0.001
+ 0.002189999575 0 0.0021899996 0.001 0.002189999625 0 0.00218999965 0.001 0.002189999675 0 0.0021899997 0.001 0.002189999725 0 0.00218999975 0.001
+ 0.002189999775 0 0.0021899998 0.001 0.002189999825 0 0.00218999985 0.001 0.002189999875 0 0.0021899999 0.001 0.002189999925 0 0.00218999995 0.001
+ 0.002189999975 0 0.00219 0.001 0.002190000025 0 0.00219000005 0.001 0.002190000075 0 0.0021900001 0.001 0.002190000125 0 0.00219000015 0.001
+ 0.002190000175 0 0.0021900002 0.001 0.002190000225 0 0.00219000025 0.001 0.002190000275 0 0.0021900003 0.001 0.002190000325 0 0.00219000035 0.001
+ 0.002190000375 0 0.0021900004 0.001 0.002190000425 0 0.00219000045 0.001 0.002190000475 0 0.0021900005 0.001 0.002190000525 0 0.00219000055 0.001
+ 0.002190000575 0 0.0021900006 0.001 0.002190000625 0 0.00219000065 0.001 0.002190000675 0 0.0021900007 0.001 0.002190000725 0 0.00219000075 0.001
+ 0.002190000775 0 0.0021900008 0.001 0.002190000825 0 0.00219000085 0.001 0.002190000875 0 0.0021900009 0.001 0.002190000925 0 0.00219000095 0.001
+ 0.002190000975 0 0.002190001 0.001 0.002190001025 0 0.00219000105 0.001 0.002190001075 0 0.0021900011 0.001 0.002190001125 0 0.00219000115 0.001
+ 0.002190001175 0 0.0021900012 0.001 0.002190001225 0 0.00219000125 0.001 0.002190001275 0 0.0021900013 0.001 0.002190001325 0 0.00219000135 0.001
+ 0.002190001375 0 0.0021900014 0.001 0.002190001425 0 0.00219000145 0.001 0.002190001475 0 0.0021900015 0.001 0.002190001525 0 0.00219000155 0.001
+ 0.002190001575 0 0.0021900016 0.001 0.002190001625 0 0.00219000165 0.001 0.002190001675 0 0.0021900017 0.001 0.002190001725 0 0.00219000175 0.001
+ 0.002190001775 0 0.0021900018 0.001 0.002190001825 0 0.00219000185 0.001 0.002190001875 0 0.0021900019 0.001 0.002190001925 0 0.00219000195 0.001
+ 0.002190001975 0 0.002190002 0.001 0.002190002025 0 0.00219000205 0.001 0.002190002075 0 0.0021900021 0.001 0.002190002125 0 0.00219000215 0.001
+ 0.002190002175 0 0.0021900022 0.001 0.002190002225 0 0.00219000225 0.001 0.002190002275 0 0.0021900023 0.001 0.002190002325 0 0.00219000235 0.001
+ 0.002190002375 0 0.0021900024 0.001 0.002190002425 0 0.00219000245 0.001 0.002190002475 0 0.0021900025 0.001 0.002190002525 0 0.00219000255 0.001
+ 0.002190002575 0 0.0021900026 0.001 0.002190002625 0 0.00219000265 0.001 0.002190002675 0 0.0021900027 0.001 0.002190002725 0 0.00219000275 0.001
+ 0.002190002775 0 0.0021900028 0.001 0.002190002825 0 0.00219000285 0.001 0.002190002875 0 0.0021900029 0.001 0.002190002925 0 0.00219000295 0.001
+ 0.002190002975 0 0.002190003 0.001 0.002199999 0 0.002199999025 0.001 0.00219999905 0 0.002199999075 0.001 0.0021999991 0 0.002199999125 0.001
+ 0.00219999915 0 0.002199999175 0.001 0.0021999992 0 0.002199999225 0.001 0.00219999925 0 0.002199999275 0.001 0.0021999993 0 0.002199999325 0.001
+ 0.00219999935 0 0.002199999375 0.001 0.0021999994 0 0.002199999425 0.001 0.00219999945 0 0.002199999475 0.001 0.0021999995 0 0.002199999525 0.001
+ 0.00219999955 0 0.002199999575 0.001 0.0021999996 0 0.002199999625 0.001 0.00219999965 0 0.002199999675 0.001 0.0021999997 0 0.002199999725 0.001
+ 0.00219999975 0 0.002199999775 0.001 0.0021999998 0 0.002199999825 0.001 0.00219999985 0 0.002199999875 0.001 0.0021999999 0 0.002199999925 0.001
+ 0.00219999995 0 0.002199999975 0.001 0.0022 0 0.002200000025 0.001 0.00220000005 0 0.002200000075 0.001 0.0022000001 0 0.002200000125 0.001
+ 0.00220000015 0 0.002200000175 0.001 0.0022000002 0 0.002200000225 0.001 0.00220000025 0 0.002200000275 0.001 0.0022000003 0 0.002200000325 0.001
+ 0.00220000035 0 0.002200000375 0.001 0.0022000004 0 0.002200000425 0.001 0.00220000045 0 0.002200000475 0.001 0.0022000005 0 0.002200000525 0.001
+ 0.00220000055 0 0.002200000575 0.001 0.0022000006 0 0.002200000625 0.001 0.00220000065 0 0.002200000675 0.001 0.0022000007 0 0.002200000725 0.001
+ 0.00220000075 0 0.002200000775 0.001 0.0022000008 0 0.002200000825 0.001 0.00220000085 0 0.002200000875 0.001 0.0022000009 0 0.002200000925 0.001
+ 0.00220000095 0 0.002200000975 0.001 0.002200001 0 0.002200001025 0.001 0.00220000105 0 0.002200001075 0.001 0.0022000011 0 0.002200001125 0.001
+ 0.00220000115 0 0.002200001175 0.001 0.0022000012 0 0.002200001225 0.001 0.00220000125 0 0.002200001275 0.001 0.0022000013 0 0.002200001325 0.001
+ 0.00220000135 0 0.002200001375 0.001 0.0022000014 0 0.002200001425 0.001 0.00220000145 0 0.002200001475 0.001 0.0022000015 0 0.002200001525 0.001
+ 0.00220000155 0 0.002200001575 0.001 0.0022000016 0 0.002200001625 0.001 0.00220000165 0 0.002200001675 0.001 0.0022000017 0 0.002200001725 0.001
+ 0.00220000175 0 0.002200001775 0.001 0.0022000018 0 0.002200001825 0.001 0.00220000185 0 0.002200001875 0.001 0.0022000019 0 0.002200001925 0.001
+ 0.00220000195 0 0.002200001975 0.001 0.002200002 0 0.002200002025 0.001 0.00220000205 0 0.002200002075 0.001 0.0022000021 0 0.002200002125 0.001
+ 0.00220000215 0 0.002200002175 0.001 0.0022000022 0 0.002200002225 0.001 0.00220000225 0 0.002200002275 0.001 0.0022000023 0 0.002200002325 0.001
+ 0.00220000235 0 0.002200002375 0.001 0.0022000024 0 0.002200002425 0.001 0.00220000245 0 0.002200002475 0.001 0.0022000025 0 0.002200002525 0.001
+ 0.00220000255 0 0.002200002575 0.001 0.0022000026 0 0.002200002625 0.001 0.00220000265 0 0.002200002675 0.001 0.0022000027 0 0.002200002725 0.001
+ 0.00220000275 0 0.002200002775 0.001 0.0022000028 0 0.002200002825 0.001 0.00220000285 0 0.002200002875 0.001 0.0022000029 0 0.002200002925 0.001
+ 0.00220000295 0 0.002200002975 0.001 0.002200003 0 0.002249999 0.001 0.002249999025 0 0.00224999905 0.001 0.002249999075 0 0.0022499991 0.001
+ 0.002249999125 0 0.00224999915 0.001 0.002249999175 0 0.0022499992 0.001 0.002249999225 0 0.00224999925 0.001 0.002249999275 0 0.0022499993 0.001
+ 0.002249999325 0 0.00224999935 0.001 0.002249999375 0 0.0022499994 0.001 0.002249999425 0 0.00224999945 0.001 0.002249999475 0 0.0022499995 0.001
+ 0.002249999525 0 0.00224999955 0.001 0.002249999575 0 0.0022499996 0.001 0.002249999625 0 0.00224999965 0.001 0.002249999675 0 0.0022499997 0.001
+ 0.002249999725 0 0.00224999975 0.001 0.002249999775 0 0.0022499998 0.001 0.002249999825 0 0.00224999985 0.001 0.002249999875 0 0.0022499999 0.001
+ 0.002249999925 0 0.00224999995 0.001 0.002249999975 0 0.00225 0.001 0.002250000025 0 0.00225000005 0.001 0.002250000075 0 0.0022500001 0.001
+ 0.002250000125 0 0.00225000015 0.001 0.002250000175 0 0.0022500002 0.001 0.002250000225 0 0.00225000025 0.001 0.002250000275 0 0.0022500003 0.001
+ 0.002250000325 0 0.00225000035 0.001 0.002250000375 0 0.0022500004 0.001 0.002250000425 0 0.00225000045 0.001 0.002250000475 0 0.0022500005 0.001
+ 0.002250000525 0 0.00225000055 0.001 0.002250000575 0 0.0022500006 0.001 0.002250000625 0 0.00225000065 0.001 0.002250000675 0 0.0022500007 0.001
+ 0.002250000725 0 0.00225000075 0.001 0.002250000775 0 0.0022500008 0.001 0.002250000825 0 0.00225000085 0.001 0.002250000875 0 0.0022500009 0.001
+ 0.002250000925 0 0.00225000095 0.001 0.002250000975 0 0.002250001 0.001 0.002250001025 0 0.00225000105 0.001 0.002250001075 0 0.0022500011 0.001
+ 0.002250001125 0 0.00225000115 0.001 0.002250001175 0 0.0022500012 0.001 0.002250001225 0 0.00225000125 0.001 0.002250001275 0 0.0022500013 0.001
+ 0.002250001325 0 0.00225000135 0.001 0.002250001375 0 0.0022500014 0.001 0.002250001425 0 0.00225000145 0.001 0.002250001475 0 0.0022500015 0.001
+ 0.002250001525 0 0.00225000155 0.001 0.002250001575 0 0.0022500016 0.001 0.002250001625 0 0.00225000165 0.001 0.002250001675 0 0.0022500017 0.001
+ 0.002250001725 0 0.00225000175 0.001 0.002250001775 0 0.0022500018 0.001 0.002250001825 0 0.00225000185 0.001 0.002250001875 0 0.0022500019 0.001
+ 0.002250001925 0 0.00225000195 0.001 0.002250001975 0 0.002250002 0.001 0.002250002025 0 0.00225000205 0.001 0.002250002075 0 0.0022500021 0.001
+ 0.002250002125 0 0.00225000215 0.001 0.002250002175 0 0.0022500022 0.001 0.002250002225 0 0.00225000225 0.001 0.002250002275 0 0.0022500023 0.001
+ 0.002250002325 0 0.00225000235 0.001 0.002250002375 0 0.0022500024 0.001 0.002250002425 0 0.00225000245 0.001 0.002250002475 0 0.0022500025 0.001
+ 0.002250002525 0 0.00225000255 0.001 0.002250002575 0 0.0022500026 0.001 0.002250002625 0 0.00225000265 0.001 0.002250002675 0 0.0022500027 0.001
+ 0.002250002725 0 0.00225000275 0.001 0.002250002775 0 0.0022500028 0.001 0.002250002825 0 0.00225000285 0.001 0.002250002875 0 0.0022500029 0.001
+ 0.002250002925 0 0.00225000295 0.001 0.002250002975 0 0.002250003 0.001 0.002250009 0 0.002250009025 0.001 0.00225000905 0 0.002250009075 0.001
+ 0.0022500091 0 0.002250009125 0.001 0.00225000915 0 0.002250009175 0.001 0.0022500092 0 0.002250009225 0.001 0.00225000925 0 0.002250009275 0.001
+ 0.0022500093 0 0.002250009325 0.001 0.00225000935 0 0.002250009375 0.001 0.0022500094 0 0.002250009425 0.001 0.00225000945 0 0.002250009475 0.001
+ 0.0022500095 0 0.002250009525 0.001 0.00225000955 0 0.002250009575 0.001 0.0022500096 0 0.002250009625 0.001 0.00225000965 0 0.002250009675 0.001
+ 0.0022500097 0 0.002250009725 0.001 0.00225000975 0 0.002250009775 0.001 0.0022500098 0 0.002250009825 0.001 0.00225000985 0 0.002250009875 0.001
+ 0.0022500099 0 0.002250009925 0.001 0.00225000995 0 0.002250009975 0.001 0.00225001 0 0.002250010025 0.001 0.00225001005 0 0.002250010075 0.001
+ 0.0022500101 0 0.002250010125 0.001 0.00225001015 0 0.002250010175 0.001 0.0022500102 0 0.002250010225 0.001 0.00225001025 0 0.002250010275 0.001
+ 0.0022500103 0 0.002250010325 0.001 0.00225001035 0 0.002250010375 0.001 0.0022500104 0 0.002250010425 0.001 0.00225001045 0 0.002250010475 0.001
+ 0.0022500105 0 0.002250010525 0.001 0.00225001055 0 0.002250010575 0.001 0.0022500106 0 0.002250010625 0.001 0.00225001065 0 0.002250010675 0.001
+ 0.0022500107 0 0.002250010725 0.001 0.00225001075 0 0.002250010775 0.001 0.0022500108 0 0.002250010825 0.001 0.00225001085 0 0.002250010875 0.001
+ 0.0022500109 0 0.002250010925 0.001 0.00225001095 0 0.002250010975 0.001 0.002250011 0 0.002250011025 0.001 0.00225001105 0 0.002250011075 0.001
+ 0.0022500111 0 0.002250011125 0.001 0.00225001115 0 0.002250011175 0.001 0.0022500112 0 0.002250011225 0.001 0.00225001125 0 0.002250011275 0.001
+ 0.0022500113 0 0.002250011325 0.001 0.00225001135 0 0.002250011375 0.001 0.0022500114 0 0.002250011425 0.001 0.00225001145 0 0.002250011475 0.001
+ 0.0022500115 0 0.002250011525 0.001 0.00225001155 0 0.002250011575 0.001 0.0022500116 0 0.002250011625 0.001 0.00225001165 0 0.002250011675 0.001
+ 0.0022500117 0 0.002250011725 0.001 0.00225001175 0 0.002250011775 0.001 0.0022500118 0 0.002250011825 0.001 0.00225001185 0 0.002250011875 0.001
+ 0.0022500119 0 0.002250011925 0.001 0.00225001195 0 0.002250011975 0.001 0.002250012 0 0.002250012025 0.001 0.00225001205 0 0.002250012075 0.001
+ 0.0022500121 0 0.002250012125 0.001 0.00225001215 0 0.002250012175 0.001 0.0022500122 0 0.002250012225 0.001 0.00225001225 0 0.002250012275 0.001
+ 0.0022500123 0 0.002250012325 0.001 0.00225001235 0 0.002250012375 0.001 0.0022500124 0 0.002250012425 0.001 0.00225001245 0 0.002250012475 0.001
+ 0.0022500125 0 0.002250012525 0.001 0.00225001255 0 0.002250012575 0.001 0.0022500126 0 0.002250012625 0.001 0.00225001265 0 0.002250012675 0.001
+ 0.0022500127 0 0.002250012725 0.001 0.00225001275 0 0.002250012775 0.001 0.0022500128 0 0.002250012825 0.001 0.00225001285 0 0.002250012875 0.001
+ 0.0022500129 0 0.002250012925 0.001 0.00225001295 0 0.002250012975 0.001 0.002250013 0 0.002299999 0.001 0.002299999025 0 0.00229999905 0.001
+ 0.002299999075 0 0.0022999991 0.001 0.002299999125 0 0.00229999915 0.001 0.002299999175 0 0.0022999992 0.001 0.002299999225 0 0.00229999925 0.001
+ 0.002299999275 0 0.0022999993 0.001 0.002299999325 0 0.00229999935 0.001 0.002299999375 0 0.0022999994 0.001 0.002299999425 0 0.00229999945 0.001
+ 0.002299999475 0 0.0022999995 0.001 0.002299999525 0 0.00229999955 0.001 0.002299999575 0 0.0022999996 0.001 0.002299999625 0 0.00229999965 0.001
+ 0.002299999675 0 0.0022999997 0.001 0.002299999725 0 0.00229999975 0.001 0.002299999775 0 0.0022999998 0.001 0.002299999825 0 0.00229999985 0.001
+ 0.002299999875 0 0.0022999999 0.001 0.002299999925 0 0.00229999995 0.001 0.002299999975 0 0.0023 0.001 0.002300000025 0 0.00230000005 0.001
+ 0.002300000075 0 0.0023000001 0.001 0.002300000125 0 0.00230000015 0.001 0.002300000175 0 0.0023000002 0.001 0.002300000225 0 0.00230000025 0.001
+ 0.002300000275 0 0.0023000003 0.001 0.002300000325 0 0.00230000035 0.001 0.002300000375 0 0.0023000004 0.001 0.002300000425 0 0.00230000045 0.001
+ 0.002300000475 0 0.0023000005 0.001 0.002300000525 0 0.00230000055 0.001 0.002300000575 0 0.0023000006 0.001 0.002300000625 0 0.00230000065 0.001
+ 0.002300000675 0 0.0023000007 0.001 0.002300000725 0 0.00230000075 0.001 0.002300000775 0 0.0023000008 0.001 0.002300000825 0 0.00230000085 0.001
+ 0.002300000875 0 0.0023000009 0.001 0.002300000925 0 0.00230000095 0.001 0.002300000975 0 0.002300001 0.001 0.002300001025 0 0.00230000105 0.001
+ 0.002300001075 0 0.0023000011 0.001 0.002300001125 0 0.00230000115 0.001 0.002300001175 0 0.0023000012 0.001 0.002300001225 0 0.00230000125 0.001
+ 0.002300001275 0 0.0023000013 0.001 0.002300001325 0 0.00230000135 0.001 0.002300001375 0 0.0023000014 0.001 0.002300001425 0 0.00230000145 0.001
+ 0.002300001475 0 0.0023000015 0.001 0.002300001525 0 0.00230000155 0.001 0.002300001575 0 0.0023000016 0.001 0.002300001625 0 0.00230000165 0.001
+ 0.002300001675 0 0.0023000017 0.001 0.002300001725 0 0.00230000175 0.001 0.002300001775 0 0.0023000018 0.001 0.002300001825 0 0.00230000185 0.001
+ 0.002300001875 0 0.0023000019 0.001 0.002300001925 0 0.00230000195 0.001 0.002300001975 0 0.002300002 0.001 0.002300002025 0 0.00230000205 0.001
+ 0.002300002075 0 0.0023000021 0.001 0.002300002125 0 0.00230000215 0.001 0.002300002175 0 0.0023000022 0.001 0.002300002225 0 0.00230000225 0.001
+ 0.002300002275 0 0.0023000023 0.001 0.002300002325 0 0.00230000235 0.001 0.002300002375 0 0.0023000024 0.001 0.002300002425 0 0.00230000245 0.001
+ 0.002300002475 0 0.0023000025 0.001 0.002300002525 0 0.00230000255 0.001 0.002300002575 0 0.0023000026 0.001 0.002300002625 0 0.00230000265 0.001
+ 0.002300002675 0 0.0023000027 0.001 0.002300002725 0 0.00230000275 0.001 0.002300002775 0 0.0023000028 0.001 0.002300002825 0 0.00230000285 0.001
+ 0.002300002875 0 0.0023000029 0.001 0.002300002925 0 0.00230000295 0.001 0.002300002975 0 0.002300003 0.001 0.002349999 0 0.002349999025 0.001
+ 0.00234999905 0 0.002349999075 0.001 0.0023499991 0 0.002349999125 0.001 0.00234999915 0 0.002349999175 0.001 0.0023499992 0 0.002349999225 0.001
+ 0.00234999925 0 0.002349999275 0.001 0.0023499993 0 0.002349999325 0.001 0.00234999935 0 0.002349999375 0.001 0.0023499994 0 0.002349999425 0.001
+ 0.00234999945 0 0.002349999475 0.001 0.0023499995 0 0.002349999525 0.001 0.00234999955 0 0.002349999575 0.001 0.0023499996 0 0.002349999625 0.001
+ 0.00234999965 0 0.002349999675 0.001 0.0023499997 0 0.002349999725 0.001 0.00234999975 0 0.002349999775 0.001 0.0023499998 0 0.002349999825 0.001
+ 0.00234999985 0 0.002349999875 0.001 0.0023499999 0 0.002349999925 0.001 0.00234999995 0 0.002349999975 0.001 0.00235 0 0.002350000025 0.001
+ 0.00235000005 0 0.002350000075 0.001 0.0023500001 0 0.002350000125 0.001 0.00235000015 0 0.002350000175 0.001 0.0023500002 0 0.002350000225 0.001
+ 0.00235000025 0 0.002350000275 0.001 0.0023500003 0 0.002350000325 0.001 0.00235000035 0 0.002350000375 0.001 0.0023500004 0 0.002350000425 0.001
+ 0.00235000045 0 0.002350000475 0.001 0.0023500005 0 0.002350000525 0.001 0.00235000055 0 0.002350000575 0.001 0.0023500006 0 0.002350000625 0.001
+ 0.00235000065 0 0.002350000675 0.001 0.0023500007 0 0.002350000725 0.001 0.00235000075 0 0.002350000775 0.001 0.0023500008 0 0.002350000825 0.001
+ 0.00235000085 0 0.002350000875 0.001 0.0023500009 0 0.002350000925 0.001 0.00235000095 0 0.002350000975 0.001 0.002350001 0 0.002350001025 0.001
+ 0.00235000105 0 0.002350001075 0.001 0.0023500011 0 0.002350001125 0.001 0.00235000115 0 0.002350001175 0.001 0.0023500012 0 0.002350001225 0.001
+ 0.00235000125 0 0.002350001275 0.001 0.0023500013 0 0.002350001325 0.001 0.00235000135 0 0.002350001375 0.001 0.0023500014 0 0.002350001425 0.001
+ 0.00235000145 0 0.002350001475 0.001 0.0023500015 0 0.002350001525 0.001 0.00235000155 0 0.002350001575 0.001 0.0023500016 0 0.002350001625 0.001
+ 0.00235000165 0 0.002350001675 0.001 0.0023500017 0 0.002350001725 0.001 0.00235000175 0 0.002350001775 0.001 0.0023500018 0 0.002350001825 0.001
+ 0.00235000185 0 0.002350001875 0.001 0.0023500019 0 0.002350001925 0.001 0.00235000195 0 0.002350001975 0.001 0.002350002 0 0.002350002025 0.001
+ 0.00235000205 0 0.002350002075 0.001 0.0023500021 0 0.002350002125 0.001 0.00235000215 0 0.002350002175 0.001 0.0023500022 0 0.002350002225 0.001
+ 0.00235000225 0 0.002350002275 0.001 0.0023500023 0 0.002350002325 0.001 0.00235000235 0 0.002350002375 0.001 0.0023500024 0 0.002350002425 0.001
+ 0.00235000245 0 0.002350002475 0.001 0.0023500025 0 0.002350002525 0.001 0.00235000255 0 0.002350002575 0.001 0.0023500026 0 0.002350002625 0.001
+ 0.00235000265 0 0.002350002675 0.001 0.0023500027 0 0.002350002725 0.001 0.00235000275 0 0.002350002775 0.001 0.0023500028 0 0.002350002825 0.001
+ 0.00235000285 0 0.002350002875 0.001 0.0023500029 0 0.002350002925 0.001 0.00235000295 0 0.002350002975 0.001 0.002350003 0 0.002399999 0.001
+ 0.002399999025 0 0.00239999905 0.001 0.002399999075 0 0.0023999991 0.001 0.002399999125 0 0.00239999915 0.001 0.002399999175 0 0.0023999992 0.001
+ 0.002399999225 0 0.00239999925 0.001 0.002399999275 0 0.0023999993 0.001 0.002399999325 0 0.00239999935 0.001 0.002399999375 0 0.0023999994 0.001
+ 0.002399999425 0 0.00239999945 0.001 0.002399999475 0 0.0023999995 0.001 0.002399999525 0 0.00239999955 0.001 0.002399999575 0 0.0023999996 0.001
+ 0.002399999625 0 0.00239999965 0.001 0.002399999675 0 0.0023999997 0.001 0.002399999725 0 0.00239999975 0.001 0.002399999775 0 0.0023999998 0.001
+ 0.002399999825 0 0.00239999985 0.001 0.002399999875 0 0.0023999999 0.001 0.002399999925 0 0.00239999995 0.001 0.002399999975 0 0.0024 0.001
+ 0.002400000025 0 0.00240000005 0.001 0.002400000075 0 0.0024000001 0.001 0.002400000125 0 0.00240000015 0.001 0.002400000175 0 0.0024000002 0.001
+ 0.002400000225 0 0.00240000025 0.001 0.002400000275 0 0.0024000003 0.001 0.002400000325 0 0.00240000035 0.001 0.002400000375 0 0.0024000004 0.001
+ 0.002400000425 0 0.00240000045 0.001 0.002400000475 0 0.0024000005 0.001 0.002400000525 0 0.00240000055 0.001 0.002400000575 0 0.0024000006 0.001
+ 0.002400000625 0 0.00240000065 0.001 0.002400000675 0 0.0024000007 0.001 0.002400000725 0 0.00240000075 0.001 0.002400000775 0 0.0024000008 0.001
+ 0.002400000825 0 0.00240000085 0.001 0.002400000875 0 0.0024000009 0.001 0.002400000925 0 0.00240000095 0.001 0.002400000975 0 0.002400001 0.001
+ 0.002400001025 0 0.00240000105 0.001 0.002400001075 0 0.0024000011 0.001 0.002400001125 0 0.00240000115 0.001 0.002400001175 0 0.0024000012 0.001
+ 0.002400001225 0 0.00240000125 0.001 0.002400001275 0 0.0024000013 0.001 0.002400001325 0 0.00240000135 0.001 0.002400001375 0 0.0024000014 0.001
+ 0.002400001425 0 0.00240000145 0.001 0.002400001475 0 0.0024000015 0.001 0.002400001525 0 0.00240000155 0.001 0.002400001575 0 0.0024000016 0.001
+ 0.002400001625 0 0.00240000165 0.001 0.002400001675 0 0.0024000017 0.001 0.002400001725 0 0.00240000175 0.001 0.002400001775 0 0.0024000018 0.001
+ 0.002400001825 0 0.00240000185 0.001 0.002400001875 0 0.0024000019 0.001 0.002400001925 0 0.00240000195 0.001 0.002400001975 0 0.002400002 0.001
+ 0.002400002025 0 0.00240000205 0.001 0.002400002075 0 0.0024000021 0.001 0.002400002125 0 0.00240000215 0.001 0.002400002175 0 0.0024000022 0.001
+ 0.002400002225 0 0.00240000225 0.001 0.002400002275 0 0.0024000023 0.001 0.002400002325 0 0.00240000235 0.001 0.002400002375 0 0.0024000024 0.001
+ 0.002400002425 0 0.00240000245 0.001 0.002400002475 0 0.0024000025 0.001 0.002400002525 0 0.00240000255 0.001 0.002400002575 0 0.0024000026 0.001
+ 0.002400002625 0 0.00240000265 0.001 0.002400002675 0 0.0024000027 0.001 0.002400002725 0 0.00240000275 0.001 0.002400002775 0 0.0024000028 0.001
+ 0.002400002825 0 0.00240000285 0.001 0.002400002875 0 0.0024000029 0.001 0.002400002925 0 0.00240000295 0.001 0.002400002975 0 0.002400003 0.001
+ 0.002449999 0 0.002449999025 0.001 0.00244999905 0 0.002449999075 0.001 0.0024499991 0 0.002449999125 0.001 0.00244999915 0 0.002449999175 0.001
+ 0.0024499992 0 0.002449999225 0.001 0.00244999925 0 0.002449999275 0.001 0.0024499993 0 0.002449999325 0.001 0.00244999935 0 0.002449999375 0.001
+ 0.0024499994 0 0.002449999425 0.001 0.00244999945 0 0.002449999475 0.001 0.0024499995 0 0.002449999525 0.001 0.00244999955 0 0.002449999575 0.001
+ 0.0024499996 0 0.002449999625 0.001 0.00244999965 0 0.002449999675 0.001 0.0024499997 0 0.002449999725 0.001 0.00244999975 0 0.002449999775 0.001
+ 0.0024499998 0 0.002449999825 0.001 0.00244999985 0 0.002449999875 0.001 0.0024499999 0 0.002449999925 0.001 0.00244999995 0 0.002449999975 0.001
+ 0.00245 0 0.002450000025 0.001 0.00245000005 0 0.002450000075 0.001 0.0024500001 0 0.002450000125 0.001 0.00245000015 0 0.002450000175 0.001
+ 0.0024500002 0 0.002450000225 0.001 0.00245000025 0 0.002450000275 0.001 0.0024500003 0 0.002450000325 0.001 0.00245000035 0 0.002450000375 0.001
+ 0.0024500004 0 0.002450000425 0.001 0.00245000045 0 0.002450000475 0.001 0.0024500005 0 0.002450000525 0.001 0.00245000055 0 0.002450000575 0.001
+ 0.0024500006 0 0.002450000625 0.001 0.00245000065 0 0.002450000675 0.001 0.0024500007 0 0.002450000725 0.001 0.00245000075 0 0.002450000775 0.001
+ 0.0024500008 0 0.002450000825 0.001 0.00245000085 0 0.002450000875 0.001 0.0024500009 0 0.002450000925 0.001 0.00245000095 0 0.002450000975 0.001
+ 0.002450001 0 0.002450001025 0.001 0.00245000105 0 0.002450001075 0.001 0.0024500011 0 0.002450001125 0.001 0.00245000115 0 0.002450001175 0.001
+ 0.0024500012 0 0.002450001225 0.001 0.00245000125 0 0.002450001275 0.001 0.0024500013 0 0.002450001325 0.001 0.00245000135 0 0.002450001375 0.001
+ 0.0024500014 0 0.002450001425 0.001 0.00245000145 0 0.002450001475 0.001 0.0024500015 0 0.002450001525 0.001 0.00245000155 0 0.002450001575 0.001
+ 0.0024500016 0 0.002450001625 0.001 0.00245000165 0 0.002450001675 0.001 0.0024500017 0 0.002450001725 0.001 0.00245000175 0 0.002450001775 0.001
+ 0.0024500018 0 0.002450001825 0.001 0.00245000185 0 0.002450001875 0.001 0.0024500019 0 0.002450001925 0.001 0.00245000195 0 0.002450001975 0.001
+ 0.002450002 0 0.002450002025 0.001 0.00245000205 0 0.002450002075 0.001 0.0024500021 0 0.002450002125 0.001 0.00245000215 0 0.002450002175 0.001
+ 0.0024500022 0 0.002450002225 0.001 0.00245000225 0 0.002450002275 0.001 0.0024500023 0 0.002450002325 0.001 0.00245000235 0 0.002450002375 0.001
+ 0.0024500024 0 0.002450002425 0.001 0.00245000245 0 0.002450002475 0.001 0.0024500025 0 0.002450002525 0.001 0.00245000255 0 0.002450002575 0.001
+ 0.0024500026 0 0.002450002625 0.001 0.00245000265 0 0.002450002675 0.001 0.0024500027 0 0.002450002725 0.001 0.00245000275 0 0.002450002775 0.001
+ 0.0024500028 0 0.002450002825 0.001 0.00245000285 0 0.002450002875 0.001 0.0024500029 0 0.002450002925 0.001 0.00245000295 0 0.002450002975 0.001
+ 0.002450003 0 0.002489999 0.001 0.002489999025 0 0.00248999905 0.001 0.002489999075 0 0.0024899991 0.001 0.002489999125 0 0.00248999915 0.001
+ 0.002489999175 0 0.0024899992 0.001 0.002489999225 0 0.00248999925 0.001 0.002489999275 0 0.0024899993 0.001 0.002489999325 0 0.00248999935 0.001
+ 0.002489999375 0 0.0024899994 0.001 0.002489999425 0 0.00248999945 0.001 0.002489999475 0 0.0024899995 0.001 0.002489999525 0 0.00248999955 0.001
+ 0.002489999575 0 0.0024899996 0.001 0.002489999625 0 0.00248999965 0.001 0.002489999675 0 0.0024899997 0.001 0.002489999725 0 0.00248999975 0.001
+ 0.002489999775 0 0.0024899998 0.001 0.002489999825 0 0.00248999985 0.001 0.002489999875 0 0.0024899999 0.001 0.002489999925 0 0.00248999995 0.001
+ 0.002489999975 0 0.00249 0.001 0.002490000025 0 0.00249000005 0.001 0.002490000075 0 0.0024900001 0.001 0.002490000125 0 0.00249000015 0.001
+ 0.002490000175 0 0.0024900002 0.001 0.002490000225 0 0.00249000025 0.001 0.002490000275 0 0.0024900003 0.001 0.002490000325 0 0.00249000035 0.001
+ 0.002490000375 0 0.0024900004 0.001 0.002490000425 0 0.00249000045 0.001 0.002490000475 0 0.0024900005 0.001 0.002490000525 0 0.00249000055 0.001
+ 0.002490000575 0 0.0024900006 0.001 0.002490000625 0 0.00249000065 0.001 0.002490000675 0 0.0024900007 0.001 0.002490000725 0 0.00249000075 0.001
+ 0.002490000775 0 0.0024900008 0.001 0.002490000825 0 0.00249000085 0.001 0.002490000875 0 0.0024900009 0.001 0.002490000925 0 0.00249000095 0.001
+ 0.002490000975 0 0.002490001 0.001 0.002490001025 0 0.00249000105 0.001 0.002490001075 0 0.0024900011 0.001 0.002490001125 0 0.00249000115 0.001
+ 0.002490001175 0 0.0024900012 0.001 0.002490001225 0 0.00249000125 0.001 0.002490001275 0 0.0024900013 0.001 0.002490001325 0 0.00249000135 0.001
+ 0.002490001375 0 0.0024900014 0.001 0.002490001425 0 0.00249000145 0.001 0.002490001475 0 0.0024900015 0.001 0.002490001525 0 0.00249000155 0.001
+ 0.002490001575 0 0.0024900016 0.001 0.002490001625 0 0.00249000165 0.001 0.002490001675 0 0.0024900017 0.001 0.002490001725 0 0.00249000175 0.001
+ 0.002490001775 0 0.0024900018 0.001 0.002490001825 0 0.00249000185 0.001 0.002490001875 0 0.0024900019 0.001 0.002490001925 0 0.00249000195 0.001
+ 0.002490001975 0 0.002490002 0.001 0.002490002025 0 0.00249000205 0.001 0.002490002075 0 0.0024900021 0.001 0.002490002125 0 0.00249000215 0.001
+ 0.002490002175 0 0.0024900022 0.001 0.002490002225 0 0.00249000225 0.001 0.002490002275 0 0.0024900023 0.001 0.002490002325 0 0.00249000235 0.001
+ 0.002490002375 0 0.0024900024 0.001 0.002490002425 0 0.00249000245 0.001 0.002490002475 0 0.0024900025 0.001 0.002490002525 0 0.00249000255 0.001
+ 0.002490002575 0 0.0024900026 0.001 0.002490002625 0 0.00249000265 0.001 0.002490002675 0 0.0024900027 0.001 0.002490002725 0 0.00249000275 0.001
+ 0.002490002775 0 0.0024900028 0.001 0.002490002825 0 0.00249000285 0.001 0.002490002875 0 0.0024900029 0.001 0.002490002925 0 0.00249000295 0.001
+ 0.002490002975 0 0.002490003 0.001 0.002499999 0 0.002499999025 0.001 0.00249999905 0 0.002499999075 0.001 0.0024999991 0 0.002499999125 0.001
+ 0.00249999915 0 0.002499999175 0.001 0.0024999992 0 0.002499999225 0.001 0.00249999925 0 0.002499999275 0.001 0.0024999993 0 0.002499999325 0.001
+ 0.00249999935 0 0.002499999375 0.001 0.0024999994 0 0.002499999425 0.001 0.00249999945 0 0.002499999475 0.001 0.0024999995 0 0.002499999525 0.001
+ 0.00249999955 0 0.002499999575 0.001 0.0024999996 0 0.002499999625 0.001 0.00249999965 0 0.002499999675 0.001 0.0024999997 0 0.002499999725 0.001
+ 0.00249999975 0 0.002499999775 0.001 0.0024999998 0 0.002499999825 0.001 0.00249999985 0 0.002499999875 0.001 0.0024999999 0 0.002499999925 0.001
+ 0.00249999995 0 0.002499999975 0.001 0.0025 0 0.002500000025 0.001 0.00250000005 0 0.002500000075 0.001 0.0025000001 0 0.002500000125 0.001
+ 0.00250000015 0 0.002500000175 0.001 0.0025000002 0 0.002500000225 0.001 0.00250000025 0 0.002500000275 0.001 0.0025000003 0 0.002500000325 0.001
+ 0.00250000035 0 0.002500000375 0.001 0.0025000004 0 0.002500000425 0.001 0.00250000045 0 0.002500000475 0.001 0.0025000005 0 0.002500000525 0.001
+ 0.00250000055 0 0.002500000575 0.001 0.0025000006 0 0.002500000625 0.001 0.00250000065 0 0.002500000675 0.001 0.0025000007 0 0.002500000725 0.001
+ 0.00250000075 0 0.002500000775 0.001 0.0025000008 0 0.002500000825 0.001 0.00250000085 0 0.002500000875 0.001 0.0025000009 0 0.002500000925 0.001
+ 0.00250000095 0 0.002500000975 0.001 0.002500001 0 0.002500001025 0.001 0.00250000105 0 0.002500001075 0.001 0.0025000011 0 0.002500001125 0.001
+ 0.00250000115 0 0.002500001175 0.001 0.0025000012 0 0.002500001225 0.001 0.00250000125 0 0.002500001275 0.001 0.0025000013 0 0.002500001325 0.001
+ 0.00250000135 0 0.002500001375 0.001 0.0025000014 0 0.002500001425 0.001 0.00250000145 0 0.002500001475 0.001 0.0025000015 0 0.002500001525 0.001
+ 0.00250000155 0 0.002500001575 0.001 0.0025000016 0 0.002500001625 0.001 0.00250000165 0 0.002500001675 0.001 0.0025000017 0 0.002500001725 0.001
+ 0.00250000175 0 0.002500001775 0.001 0.0025000018 0 0.002500001825 0.001 0.00250000185 0 0.002500001875 0.001 0.0025000019 0 0.002500001925 0.001
+ 0.00250000195 0 0.002500001975 0.001 0.002500002 0 0.002500002025 0.001 0.00250000205 0 0.002500002075 0.001 0.0025000021 0 0.002500002125 0.001
+ 0.00250000215 0 0.002500002175 0.001 0.0025000022 0 0.002500002225 0.001 0.00250000225 0 0.002500002275 0.001 0.0025000023 0 0.002500002325 0.001
+ 0.00250000235 0 0.002500002375 0.001 0.0025000024 0 0.002500002425 0.001 0.00250000245 0 0.002500002475 0.001 0.0025000025 0 0.002500002525 0.001
+ 0.00250000255 0 0.002500002575 0.001 0.0025000026 0 0.002500002625 0.001 0.00250000265 0 0.002500002675 0.001 0.0025000027 0 0.002500002725 0.001
+ 0.00250000275 0 0.002500002775 0.001 0.0025000028 0 0.002500002825 0.001 0.00250000285 0 0.002500002875 0.001 0.0025000029 0 0.002500002925 0.001
+ 0.00250000295 0 0.002500002975 0.001 0.002500003 0)
RBK BK 0 1k
* carga de PORB: R_B de ~25 FF + XOUT + cableado
CPORB PORB 0 100f

.control
tran 1n 2500u 0 100n
let T = 100u
let VM = 1.2/2
let ok = 1
* --- segmento 0: delta = -50u ---
let tP0=-1
let tQ0=-1
let tG0=-1
let tF0=-1
meas tran tP0 when v(porb)=VM rise=1 from=0.0001 to=0.000385
meas tran tQ0 when v(xdut.p1)=VM rise=1 from=0.0001 to=0.000385
meas tran tG0 when v(porb)=VM rise=2 from=0.0001 to=0.000385
meas tran tF0 when v(porb)=VM fall=1 from=0.00039 to=0.000395
let d0 = (tP0 - 0.0001)/T
let ph0 = (tP0 - 50u) - T*floor((tP0 - 50u)/T + 0.5)
let q0 = (tP0 - tQ0 - T)
let a0 = tF0 - 0.00039
let p0 = (tP0 gt 0) & (d0 ge 0.999) & (d0 le 2.0005) & (ph0 ge 0) & (ph0 le 20n) & (abs(q0) le 20n) & (tG0 lt 0) & (tF0 gt 0) & (a0 le 100n)
let ok = ok & p0
* --- segmento 1: delta = -1u ---
let tP1=-1
let tQ1=-1
let tG1=-1
let tF1=-1
meas tran tP1 when v(porb)=VM rise=1 from=0.000449 to=0.000685
meas tran tQ1 when v(xdut.p1)=VM rise=1 from=0.000449 to=0.000685
meas tran tG1 when v(porb)=VM rise=2 from=0.000449 to=0.000685
meas tran tF1 when v(porb)=VM fall=1 from=0.00069 to=0.000695
let d1 = (tP1 - 0.000449)/T
let ph1 = (tP1 - 50u) - T*floor((tP1 - 50u)/T + 0.5)
let q1 = (tP1 - tQ1 - T)
let a1 = tF1 - 0.00069
let p1 = (tP1 gt 0) & (d1 ge 0.999) & (d1 le 2.0005) & (ph1 ge 0) & (ph1 le 20n) & (abs(q1) le 20n) & (tG1 lt 0) & (tF1 gt 0) & (a1 le 100n)
let ok = ok & p1
* --- segmento 2: delta = -100n ---
let tP2=-1
let tQ2=-1
let tG2=-1
let tF2=-1
meas tran tP2 when v(porb)=VM rise=1 from=0.0007499 to=0.000985
meas tran tQ2 when v(xdut.p1)=VM rise=1 from=0.0007499 to=0.000985
meas tran tG2 when v(porb)=VM rise=2 from=0.0007499 to=0.000985
meas tran tF2 when v(porb)=VM fall=1 from=0.00099 to=0.000995
let d2 = (tP2 - 0.0007499)/T
let ph2 = (tP2 - 50u) - T*floor((tP2 - 50u)/T + 0.5)
let q2 = (tP2 - tQ2 - T)
let a2 = tF2 - 0.00099
let p2 = (tP2 gt 0) & (d2 ge 0.999) & (d2 le 2.0005) & (ph2 ge 0) & (ph2 le 20n) & (abs(q2) le 20n) & (tG2 lt 0) & (tF2 gt 0) & (a2 le 100n)
let ok = ok & p2
* --- segmento 3: delta = -10n ---
let tP3=-1
let tQ3=-1
let tG3=-1
let tF3=-1
meas tran tP3 when v(porb)=VM rise=1 from=0.00104999 to=0.001285
meas tran tQ3 when v(xdut.p1)=VM rise=1 from=0.00104999 to=0.001285
meas tran tG3 when v(porb)=VM rise=2 from=0.00104999 to=0.001285
meas tran tF3 when v(porb)=VM fall=1 from=0.00129 to=0.001295
let d3 = (tP3 - 0.00104999)/T
let ph3 = (tP3 - 50u) - T*floor((tP3 - 50u)/T + 0.5)
let q3 = (tP3 - tQ3 - T)
let a3 = tF3 - 0.00129
let p3 = (tP3 gt 0) & (d3 ge 0.999) & (d3 le 2.0005) & (ph3 ge 0) & (ph3 le 20n) & (abs(q3) le 20n) & (tG3 lt 0) & (tF3 gt 0) & (a3 le 100n)
let ok = ok & p3
* --- segmento 4: delta = -1n ---
let tP4=-1
let tQ4=-1
let tG4=-1
let tF4=-1
meas tran tP4 when v(porb)=VM rise=1 from=0.001349999 to=0.001585
meas tran tQ4 when v(xdut.p1)=VM rise=1 from=0.001349999 to=0.001585
meas tran tG4 when v(porb)=VM rise=2 from=0.001349999 to=0.001585
meas tran tF4 when v(porb)=VM fall=1 from=0.00159 to=0.001595
let d4 = (tP4 - 0.001349999)/T
let ph4 = (tP4 - 50u) - T*floor((tP4 - 50u)/T + 0.5)
let q4 = (tP4 - tQ4 - T)
let a4 = tF4 - 0.00159
let p4 = (tP4 gt 0) & (d4 ge 0.999) & (d4 le 2.0005) & (ph4 ge 0) & (ph4 le 20n) & (abs(q4) le 20n) & (tG4 lt 0) & (tF4 gt 0) & (a4 le 100n)
let ok = ok & p4
* --- segmento 5: delta = 0 ---
let tP5=-1
let tQ5=-1
let tG5=-1
let tF5=-1
meas tran tP5 when v(porb)=VM rise=1 from=0.00165 to=0.001885
meas tran tQ5 when v(xdut.p1)=VM rise=1 from=0.00165 to=0.001885
meas tran tG5 when v(porb)=VM rise=2 from=0.00165 to=0.001885
meas tran tF5 when v(porb)=VM fall=1 from=0.00189 to=0.001895
let d5 = (tP5 - 0.00165)/T
let ph5 = (tP5 - 50u) - T*floor((tP5 - 50u)/T + 0.5)
let q5 = (tP5 - tQ5 - T)
let a5 = tF5 - 0.00189
let p5 = (tP5 gt 0) & (d5 ge 0.999) & (d5 le 2.0005) & (ph5 ge 0) & (ph5 le 20n) & (abs(q5) le 20n) & (tG5 lt 0) & (tF5 gt 0) & (a5 le 100n)
let ok = ok & p5
* --- segmento 6: delta = 1n ---
let tP6=-1
let tQ6=-1
let tG6=-1
let tF6=-1
meas tran tP6 when v(porb)=VM rise=1 from=0.001950001 to=0.002185
meas tran tQ6 when v(xdut.p1)=VM rise=1 from=0.001950001 to=0.002185
meas tran tG6 when v(porb)=VM rise=2 from=0.001950001 to=0.002185
meas tran tF6 when v(porb)=VM fall=1 from=0.00219 to=0.002195
let d6 = (tP6 - 0.001950001)/T
let ph6 = (tP6 - 50u) - T*floor((tP6 - 50u)/T + 0.5)
let q6 = (tP6 - tQ6 - T)
let a6 = tF6 - 0.00219
let p6 = (tP6 gt 0) & (d6 ge 0.999) & (d6 le 2.0005) & (ph6 ge 0) & (ph6 le 20n) & (abs(q6) le 20n) & (tG6 lt 0) & (tF6 gt 0) & (a6 le 100n)
let ok = ok & p6
* --- segmento 7: delta = 10n ---
let tP7=-1
let tQ7=-1
let tG7=-1
let tF7=-1
meas tran tP7 when v(porb)=VM rise=1 from=0.00225001 to=0.002485
meas tran tQ7 when v(xdut.p1)=VM rise=1 from=0.00225001 to=0.002485
meas tran tG7 when v(porb)=VM rise=2 from=0.00225001 to=0.002485
meas tran tF7 when v(porb)=VM fall=1 from=0.00249 to=0.002495
let d7 = (tP7 - 0.00225001)/T
let ph7 = (tP7 - 50u) - T*floor((tP7 - 50u)/T + 0.5)
let q7 = (tP7 - tQ7 - T)
let a7 = tF7 - 0.00249
let p7 = (tP7 gt 0) & (d7 ge 0.999) & (d7 le 2.0005) & (ph7 ge 0) & (ph7 le 20n) & (abs(q7) le 20n) & (tG7 lt 0) & (tF7 gt 0) & (a7 le 100n)
let ok = ok & p7
echo RESULT_BEGIN
print d0 d1 d2 d3 d4 d5 d6 d7
print ph0 ph1 ph2 ph3 ph4 ph5 ph6 ph7
print q0 q1 q2 q3 q4 q5 q6 q7
print a0 a1 a2 a3 a4 a5 a6 a7
print p0 p1 p2 p3 p4 p5 p6 p7 ok
echo RESULT_END
if ok > 0.5
  echo VEREDICTO: PASS
else
  echo VEREDICTO: FAIL
end
plot v(clk) v(por_raw_n) v(xdut.p1)+1.5 v(porb)+3
.endc
.end
